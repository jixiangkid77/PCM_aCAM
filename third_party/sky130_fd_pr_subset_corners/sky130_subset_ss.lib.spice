* Subset of the SkyWater sky130 primitive models (slow-slow corner) for ngspice.
* Source: https://github.com/google/skywater-pdk-libs-sky130_fd_pr commit f62031a1be9aefe902d6d54cddd6f59b57627436 (Apache-2.0, see LICENSE).
* Devices: sky130_fd_pr__nfet_01v8, sky130_fd_pr__nfet_01v8_lvt.
* Patch: per-instance mismatch parameters mm_vth0, mm_toxe, mm_voff, mm_nfactor (see src/pcm_acam/sky130_models.py).
.option scale=1.0u
.include "lod.spice"
.param lv_dlc_rotweak = 0.0 lvt_dlc_rotweak = 0.0
.param sky130_fd_pr__nfet_01v8__dlc_rotweak = lv_dlc_rotweak
.param sky130_fd_pr__nfet_01v8_lvt__dlc_rotweak = lvt_dlc_rotweak
.include "sky130_fd_pr__nfet_01v8__mismatch.corner.spice"
.include "sky130_fd_pr__nfet_01v8_lvt__mismatch.corner.spice"
.include "sky130_fd_pr__nfet_01v8__ss.corner.spice"
.include "sky130_fd_pr__nfet_01v8_lvt__ss.corner.spice"
