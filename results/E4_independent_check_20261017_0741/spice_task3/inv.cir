* E4 independent: INV_S transfer curves
.include "/home/claude/PCM_aCAM/third_party/sky130_fd_pr_subset_e3b/sky130_subset_tt.lib.spice"
.options reltol=1e-7 abstol=1e-16 vntol=1e-10

VDD vdd 0 1.8
VIN in 0 0.57
XPu0 ou0 in vdd vdd sky130_fd_pr__pfet_01v8 w=0.42 l=4.0
XNu0 ou0 in 0 0 sky130_fd_pr__nfet_01v8 w=2.0 l=0.15
XPu1 ou1 in vdd vdd sky130_fd_pr__pfet_01v8 w=0.42 l=4.0 mm_vth0=-0.67858250398120479 mm_toxe=-1.0494487652392783 mm_voff=-1.2451474993450375 mm_nfactor=-1.0545132415189984
XNu1 ou1 in 0 0 sky130_fd_pr__nfet_01v8 w=2.0 l=0.15 mm_vth0=0.78942031743448515 mm_toxe=-0.42742926630218658 mm_voff=0.2846331872570575 mm_nfactor=-0.3626841482548569
XPu2 ou2 in vdd vdd sky130_fd_pr__pfet_01v8 w=0.42 l=4.0 mm_vth0=-0.30258690675385852 mm_toxe=-0.26703465255902714 mm_voff=0.5880810094276363 mm_nfactor=-0.8744649949124772
XNu2 ou2 in 0 0 sky130_fd_pr__nfet_01v8 w=2.0 l=0.15 mm_vth0=-0.10122313581980176 mm_toxe=-0.59818453179369779 mm_voff=-1.0257627504858728 mm_nfactor=-0.47812811642371805
XPu3 ou3 in vdd vdd sky130_fd_pr__pfet_01v8 w=0.42 l=4.0 mm_vth0=1.3904291698907916 mm_toxe=1.7515403608674267 mm_voff=0.20762673194012088 mm_nfactor=1.0265587332191477
XNu3 ou3 in 0 0 sky130_fd_pr__nfet_01v8 w=2.0 l=0.15 mm_vth0=0.12987177599051272 mm_toxe=-0.89766010817364006 mm_voff=-0.23571536729084633 mm_nfactor=1.2467407927995817
XPu4 ou4 in vdd vdd sky130_fd_pr__pfet_01v8 w=0.42 l=4.0 mm_vth0=-1.2164036944111591 mm_toxe=-0.66825636778345809 mm_voff=0.28847488444721031 mm_nfactor=-0.47784407617958202
XNu4 ou4 in 0 0 sky130_fd_pr__nfet_01v8 w=2.0 l=0.15 mm_vth0=0.24041869429394133 mm_toxe=-1.6063624210028893 mm_voff=-0.30271441112639019 mm_nfactor=0.33118239473257322
XPu5 ou5 in vdd vdd sky130_fd_pr__pfet_01v8 w=0.42 l=4.0 mm_vth0=-1.2357355609893237 mm_toxe=0.60344799345493016 mm_voff=1.548259103448504 mm_nfactor=0.47834287955233823
XNu5 ou5 in 0 0 sky130_fd_pr__nfet_01v8 w=2.0 l=0.15 mm_vth0=1.4345299484444185 mm_toxe=0.51011041985503025 mm_voff=0.19317009954933065 mm_nfactor=-0.65324945260620337
XPu6 ou6 in vdd vdd sky130_fd_pr__pfet_01v8 w=0.42 l=4.0 mm_vth0=0.1867229568655551 mm_toxe=-0.64432268738019982 mm_voff=2.2110798671134302 mm_nfactor=1.2516120114419267
XNu6 ou6 in 0 0 sky130_fd_pr__nfet_01v8 w=2.0 l=0.15 mm_vth0=0.69612444732154377 mm_toxe=-0.30099931655284889 mm_voff=-0.37448420795685805 mm_nfactor=0.19874680972440162
XPu7 ou7 in vdd vdd sky130_fd_pr__pfet_01v8 w=0.42 l=4.0 mm_vth0=-0.49058139588572064 mm_toxe=-0.40294330177377324 mm_voff=1.5571578262974077 mm_nfactor=-0.17480699270808581
XNu7 ou7 in 0 0 sky130_fd_pr__nfet_01v8 w=2.0 l=0.15 mm_vth0=-0.76975653788866472 mm_toxe=-0.43015961913832812 mm_voff=1.2159212942885913 mm_nfactor=0.75044219236012055
XPu8 ou8 in vdd vdd sky130_fd_pr__pfet_01v8 w=0.42 l=4.0 mm_vth0=0.95716645187919214 mm_toxe=-1.5890336905520115 mm_voff=0.78906313022518637 mm_nfactor=-1.8724359401794846
XNu8 ou8 in 0 0 sky130_fd_pr__nfet_01v8 w=2.0 l=0.15 mm_vth0=-0.26256365562903611 mm_toxe=0.05440905835610356 mm_voff=-2.5352172674814137 mm_nfactor=0.077810498867467576
XPu9 ou9 in vdd vdd sky130_fd_pr__pfet_01v8 w=0.42 l=4.0 mm_vth0=1.0158970161020693 mm_toxe=-0.84080899119231933 mm_voff=-1.7648077660888499 mm_nfactor=0.30019509494042657
XNu9 ou9 in 0 0 sky130_fd_pr__nfet_01v8 w=2.0 l=0.15 mm_vth0=-0.68058455080333535 mm_toxe=0.59085044086994665 mm_voff=-0.69106238340240633 mm_nfactor=-0.60696446649020441
XPu10 ou10 in vdd vdd sky130_fd_pr__pfet_01v8 w=0.42 l=4.0 mm_vth0=-0.601553894460366 mm_toxe=0.99449930583759427 mm_voff=-0.21114280784522974 mm_nfactor=0.81191664909567607
XNu10 ou10 in 0 0 sky130_fd_pr__nfet_01v8 w=2.0 l=0.15 mm_vth0=0.5297471535088295 mm_toxe=1.3915654779034543 mm_voff=-0.60639350643778056 mm_nfactor=0.0080214102933101605
XPu11 ou11 in vdd vdd sky130_fd_pr__pfet_01v8 w=0.42 l=4.0 mm_vth0=-0.96989201424699523 mm_toxe=-0.68175647467200684 mm_voff=0.99495452563125164 mm_nfactor=-0.074070289386932206
XNu11 ou11 in 0 0 sky130_fd_pr__nfet_01v8 w=2.0 l=0.15 mm_vth0=-0.75136535043368446 mm_toxe=0.71756051947887867 mm_voff=0.44250192346512829 mm_nfactor=1.0983493189908642
XPu12 ou12 in vdd vdd sky130_fd_pr__pfet_01v8 w=0.42 l=4.0 mm_vth0=0.24594813415168634 mm_toxe=1.8804674778432275 mm_voff=-0.077291541324411836 mm_nfactor=-0.4994583940791355
XNu12 ou12 in 0 0 sky130_fd_pr__nfet_01v8 w=2.0 l=0.15 mm_vth0=-0.65853968500097437 mm_toxe=-0.37132980073850008 mm_voff=1.3420734356960351 mm_nfactor=0.27652611051546333
XPu13 ou13 in vdd vdd sky130_fd_pr__pfet_01v8 w=0.42 l=4.0 mm_vth0=0.086862778826518647 mm_toxe=0.53711091347694306 mm_voff=-0.60526853066889008 mm_nfactor=1.2132008558286365
XNu13 ou13 in 0 0 sky130_fd_pr__nfet_01v8 w=2.0 l=0.15 mm_vth0=0.0012180388215939678 mm_toxe=-1.7382420919645813 mm_voff=1.506778968534181 mm_nfactor=-1.3793254092171543
XPu14 ou14 in vdd vdd sky130_fd_pr__pfet_01v8 w=0.42 l=4.0 mm_vth0=1.3153012520326164 mm_toxe=0.52455959257414231 mm_voff=-0.1292813086071001 mm_nfactor=-2.0252887566490139
XNu14 ou14 in 0 0 sky130_fd_pr__nfet_01v8 w=2.0 l=0.15 mm_vth0=0.71588273842491612 mm_toxe=-0.12619765852989273 mm_voff=1.3755756697049779 mm_nfactor=0.55400054938405874
XPu15 ou15 in vdd vdd sky130_fd_pr__pfet_01v8 w=0.42 l=4.0 mm_vth0=-0.92100963705489591 mm_toxe=-0.62065895786279612 mm_voff=-1.4529548701315993 mm_nfactor=1.102850753274321
XNu15 ou15 in 0 0 sky130_fd_pr__nfet_01v8 w=2.0 l=0.15 mm_vth0=0.32905342080808414 mm_toxe=0.11039220988139947 mm_voff=0.9309314710195854 mm_nfactor=-1.2286621554069976
XPu16 ou16 in vdd vdd sky130_fd_pr__pfet_01v8 w=0.42 l=4.0 mm_vth0=-1.8121169512999495 mm_toxe=-0.40463145847647131 mm_voff=-0.58515878387366138 mm_nfactor=1.0236353766711808
XNu16 ou16 in 0 0 sky130_fd_pr__nfet_01v8 w=2.0 l=0.15 mm_vth0=-0.047222620578199648 mm_toxe=1.2690193342920526 mm_voff=0.60127295350770049 mm_nfactor=0.5837997591302323
XPu17 ou17 in vdd vdd sky130_fd_pr__pfet_01v8 w=0.42 l=4.0 mm_vth0=1.3594874838661637 mm_toxe=0.19513455170296073 mm_voff=1.6954699329848055 mm_nfactor=-0.13783734732092934
XNu17 ou17 in 0 0 sky130_fd_pr__nfet_01v8 w=2.0 l=0.15 mm_vth0=0.56265716105000041 mm_toxe=-0.42127598176374448 mm_voff=3.0128541921270595 mm_nfactor=0.32532550427120505
XPu18 ou18 in vdd vdd sky130_fd_pr__pfet_01v8 w=0.42 l=4.0 mm_vth0=1.5387791224489469 mm_toxe=-0.11363705646795252 mm_voff=0.37493364286430253 mm_nfactor=0.90260479705052832
XNu18 ou18 in 0 0 sky130_fd_pr__nfet_01v8 w=2.0 l=0.15 mm_vth0=-0.21039941932576359 mm_toxe=0.19891064293078403 mm_voff=-0.44734811991002305 mm_nfactor=0.40097111835705512
XPu19 ou19 in vdd vdd sky130_fd_pr__pfet_01v8 w=0.42 l=4.0 mm_vth0=-0.14385539561179481 mm_toxe=1.3267955998392187 mm_voff=-2.211807885960273 mm_nfactor=1.575874502501281
XNu19 ou19 in 0 0 sky130_fd_pr__nfet_01v8 w=2.0 l=0.15 mm_vth0=-1.2071210836188628 mm_toxe=1.1623163028890404 mm_voff=-1.4497329582897791 mm_nfactor=-0.45434715198668862
XPu20 ou20 in vdd vdd sky130_fd_pr__pfet_01v8 w=0.42 l=4.0 mm_vth0=0.35856588445911514 mm_toxe=-0.21210900381368869 mm_voff=-0.29123571239887436 mm_nfactor=0.53355758278396126
XNu20 ou20 in 0 0 sky130_fd_pr__nfet_01v8 w=2.0 l=0.15 mm_vth0=-0.94054185609225793 mm_toxe=0.79570290606907923 mm_voff=0.28168447354951665 mm_nfactor=-0.4335382182598011
XPb11 ob11 in vdd vdd sky130_fd_pr__pfet_01v8 w=0.42 l=4.0 mm_vth0=-0.7159976018518911 mm_toxe=0.91633493875834293 mm_voff=0.38217940515412557 mm_nfactor=-0.78263941259838843
XNb11 ob11 in 0 0 sky130_fd_pr__nfet_01v8 w=2.0 l=0.15 mm_vth0=-2.5094015651235657 mm_toxe=-0.20485669295465764 mm_voff=-0.23701172227432701 mm_nfactor=1.1389798054007005
XPb12 ob12 in vdd vdd sky130_fd_pr__pfet_01v8 w=0.42 l=4.0 mm_vth0=-0.65028688325447315 mm_toxe=-0.67522947810581901 mm_voff=0.53917437260471768 mm_nfactor=-0.87065881493702413
XNb12 ob12 in 0 0 sky130_fd_pr__nfet_01v8 w=2.0 l=0.15 mm_vth0=1.6818177944675545 mm_toxe=-1.216353574515816 mm_voff=-0.38819405139014074 mm_nfactor=0.75601796044172842
XPb13 ob13 in vdd vdd sky130_fd_pr__pfet_01v8 w=0.42 l=4.0 mm_vth0=-1.1204623450153621 mm_toxe=-0.62637431553311818 mm_voff=-0.27738674764960319 mm_nfactor=0.84766456457282124
XNb13 ob13 in 0 0 sky130_fd_pr__nfet_01v8 w=2.0 l=0.15 mm_vth0=-1.4423812481547262 mm_toxe=-0.80892906814523524 mm_voff=1.7925994756611081 mm_nfactor=-0.080988720889711541
XPb14 ob14 in vdd vdd sky130_fd_pr__pfet_01v8 w=0.42 l=4.0 mm_vth0=0.38834881792935638 mm_toxe=-2.1081855748787883 mm_voff=-2.0043848989496098 mm_nfactor=0.096446308221530191
XNb14 ob14 in 0 0 sky130_fd_pr__nfet_01v8 w=2.0 l=0.15 mm_vth0=0.58643129624120394 mm_toxe=-0.96832666821716229 mm_voff=-2.2435207949815936 mm_nfactor=-0.24699550870145229
XPb15 ob15 in vdd vdd sky130_fd_pr__pfet_01v8 w=0.42 l=4.0 mm_vth0=0.47502978745452423 mm_toxe=0.030076901458475643 mm_voff=0.041169045204294319 mm_nfactor=0.056622264341372616
XNb15 ob15 in 0 0 sky130_fd_pr__nfet_01v8 w=2.0 l=0.15 mm_vth0=1.8449555270751081 mm_toxe=-1.058845764999943 mm_voff=0.19655008085357528 mm_nfactor=0.2779435867251836
XPb16 ob16 in vdd vdd sky130_fd_pr__pfet_01v8 w=0.42 l=4.0 mm_vth0=0.70962400884232013 mm_toxe=-1.0316266687074409 mm_voff=1.1361963023804846 mm_nfactor=-0.82036691559353925
XNb16 ob16 in 0 0 sky130_fd_pr__nfet_01v8 w=2.0 l=0.15 mm_vth0=1.4651765580367628 mm_toxe=1.4365070859147415 mm_voff=-0.31335323054541731 mm_nfactor=-0.99446611872598589
XPb17 ob17 in vdd vdd sky130_fd_pr__pfet_01v8 w=0.42 l=4.0 mm_vth0=0.49808908578141681 mm_toxe=-0.82493623999754107 mm_voff=-0.16747523383361915 mm_nfactor=-0.57808856769625183
XNb17 ob17 in 0 0 sky130_fd_pr__nfet_01v8 w=2.0 l=0.15 mm_vth0=0.96770714714659578 mm_toxe=-0.34234798774695929 mm_voff=1.5105080909083177 mm_nfactor=-0.36294891304778265
XPb18 ob18 in vdd vdd sky130_fd_pr__pfet_01v8 w=0.42 l=4.0 mm_vth0=0.97080513821297643 mm_toxe=0.59998616626881218 mm_voff=0.50739117129807687 mm_nfactor=0.10614442667966073
XNb18 ob18 in 0 0 sky130_fd_pr__nfet_01v8 w=2.0 l=0.15 mm_vth0=0.66519628568718481 mm_toxe=0.23009392103236712 mm_voff=-0.38212904490396205 mm_nfactor=-2.1776849482026353
XPb19 ob19 in vdd vdd sky130_fd_pr__pfet_01v8 w=0.42 l=4.0 mm_vth0=-0.78191756459773609 mm_toxe=0.55196260007586306 mm_voff=0.073847752149153248 mm_nfactor=0.18869211283721257
XNb19 ob19 in 0 0 sky130_fd_pr__nfet_01v8 w=2.0 l=0.15 mm_vth0=-2.7949230922850314 mm_toxe=0.62239482663160406 mm_voff=-0.025030348089303153 mm_nfactor=-1.1138365600239384
XPb110 ob110 in vdd vdd sky130_fd_pr__pfet_01v8 w=0.42 l=4.0 mm_vth0=0.36814340761904935 mm_toxe=-0.82428309072021888 mm_voff=-1.8851409209129713 mm_nfactor=0.54110130842381188
XNb110 ob110 in 0 0 sky130_fd_pr__nfet_01v8 w=2.0 l=0.15 mm_vth0=0.80243496548507609 mm_toxe=0.06885553738985796 mm_voff=0.43267437656067526 mm_nfactor=2.1663477012771115
XPb111 ob111 in vdd vdd sky130_fd_pr__pfet_01v8 w=0.42 l=4.0 mm_vth0=1.2582657232413827 mm_toxe=1.5156927594465837 mm_voff=0.65797589704488646 mm_nfactor=-1.3210638250487268
XNb111 ob111 in 0 0 sky130_fd_pr__nfet_01v8 w=2.0 l=0.15 mm_vth0=0.24656421639840834 mm_toxe=-0.74118313626278698 mm_voff=0.023158411264845087 mm_nfactor=-0.3021423408834466
XPb112 ob112 in vdd vdd sky130_fd_pr__pfet_01v8 w=0.42 l=4.0 mm_vth0=0.50297446512825117 mm_toxe=1.0785692005849599 mm_voff=1.5370526123211909 mm_nfactor=-1.0855420392718604
XNb112 ob112 in 0 0 sky130_fd_pr__nfet_01v8 w=2.0 l=0.15 mm_vth0=0.34048777796636304 mm_toxe=-0.66382207441628172 mm_voff=-0.2828277310168627 mm_nfactor=1.329448953765936
XPb113 ob113 in vdd vdd sky130_fd_pr__pfet_01v8 w=0.42 l=4.0 mm_vth0=0.61977729657532499 mm_toxe=-1.0596771142044379 mm_voff=-0.50345021231171661 mm_nfactor=2.0679907487724307
XNb113 ob113 in 0 0 sky130_fd_pr__nfet_01v8 w=2.0 l=0.15 mm_vth0=-0.16736301558384351 mm_toxe=-0.11976505840945938 mm_voff=-0.13194850181114431 mm_nfactor=-2.4381236280436074
XPb114 ob114 in vdd vdd sky130_fd_pr__pfet_01v8 w=0.42 l=4.0 mm_vth0=1.7329274617100736 mm_toxe=2.3254675225805603 mm_voff=-2.1192196745246532 mm_nfactor=0.45724520875217317
XNb114 ob114 in 0 0 sky130_fd_pr__nfet_01v8 w=2.0 l=0.15 mm_vth0=0.61751691027552946 mm_toxe=-0.12960182265797651 mm_voff=1.651953612489556 mm_nfactor=-0.96449592111830484
XPb115 ob115 in vdd vdd sky130_fd_pr__pfet_01v8 w=0.42 l=4.0 mm_vth0=-1.0318458216754944 mm_toxe=0.64819482097223302 mm_voff=-1.2474663518506788 mm_nfactor=-0.4653704473778944
XNb115 ob115 in 0 0 sky130_fd_pr__nfet_01v8 w=2.0 l=0.15 mm_vth0=-1.5653112926586723 mm_toxe=-0.98840866924276827 mm_voff=0.81420917199587661 mm_nfactor=2.852379425161526
XPb116 ob116 in vdd vdd sky130_fd_pr__pfet_01v8 w=0.42 l=4.0 mm_vth0=1.8770077524946205 mm_toxe=-1.3827054502397895 mm_voff=1.3488448222572609 mm_nfactor=-0.56459265401803616
XNb116 ob116 in 0 0 sky130_fd_pr__nfet_01v8 w=2.0 l=0.15 mm_vth0=-0.41135972623200412 mm_toxe=1.117848002807367 mm_voff=-0.50702432134660591 mm_nfactor=0.95711563580274295
XPb117 ob117 in vdd vdd sky130_fd_pr__pfet_01v8 w=0.42 l=4.0 mm_vth0=1.2664681510892006 mm_toxe=-0.16705619724662513 mm_voff=0.47927244319004103 mm_nfactor=0.59189942387622496
XNb117 ob117 in 0 0 sky130_fd_pr__nfet_01v8 w=2.0 l=0.15 mm_vth0=-0.020937990079597769 mm_toxe=-1.797510785924413 mm_voff=1.452488684111491 mm_nfactor=1.1810456271332637
XPb118 ob118 in vdd vdd sky130_fd_pr__pfet_01v8 w=0.42 l=4.0 mm_vth0=0.15638891531083032 mm_toxe=1.5557831133026494 mm_voff=0.79156388472918859 mm_nfactor=-0.20729835993465903
XNb118 ob118 in 0 0 sky130_fd_pr__nfet_01v8 w=2.0 l=0.15 mm_vth0=0.42447645055180944 mm_toxe=-0.052098755602656921 mm_voff=0.33800418351512107 mm_nfactor=-1.2461716572353223
XPb119 ob119 in vdd vdd sky130_fd_pr__pfet_01v8 w=0.42 l=4.0 mm_vth0=1.04740834049507 mm_toxe=0.50345058515637509 mm_voff=-0.88183702867727209 mm_nfactor=-0.34729909129700348
XNb119 ob119 in 0 0 sky130_fd_pr__nfet_01v8 w=2.0 l=0.15 mm_vth0=1.3649439801408167 mm_toxe=1.3214038974305018 mm_voff=-0.71281009715909882 mm_nfactor=-1.0655478884025036
XPb120 ob120 in vdd vdd sky130_fd_pr__pfet_01v8 w=0.42 l=4.0 mm_vth0=0.23898230244223481 mm_toxe=0.78597908559215035 mm_voff=0.084695602820119648 mm_nfactor=0.16255115524874572
XNb120 ob120 in 0 0 sky130_fd_pr__nfet_01v8 w=2.0 l=0.15 mm_vth0=-0.65219551158255928 mm_toxe=-0.11922529314239091 mm_voff=-1.4715670860915702 mm_nfactor=-0.83576069014554344
XPb21 ob21 in vdd vdd sky130_fd_pr__pfet_01v8 w=0.42 l=4.0 mm_vth0=-1.6909740675919527 mm_toxe=0.094771108666066625 mm_voff=-0.35842133548201383 mm_nfactor=-2.1956374210756411
XNb21 ob21 in 0 0 sky130_fd_pr__nfet_01v8 w=2.0 l=0.15 mm_vth0=-0.051289148490980881 mm_toxe=0.11115599417599423 mm_voff=0.61817292039208693 mm_nfactor=-0.68501580790578898
XPb22 ob22 in vdd vdd sky130_fd_pr__pfet_01v8 w=0.42 l=4.0 mm_vth0=-0.39277150865279314 mm_toxe=-0.25596035467395395 mm_voff=1.2756195756151518 mm_nfactor=-0.25024185125087217
XNb22 ob22 in 0 0 sky130_fd_pr__nfet_01v8 w=2.0 l=0.15 mm_vth0=-1.2769676014585492 mm_toxe=-0.089652419364505437 mm_voff=0.91764565299629797 mm_nfactor=-0.75792546272775851
XPb23 ob23 in vdd vdd sky130_fd_pr__pfet_01v8 w=0.42 l=4.0 mm_vth0=-0.42889983469928661 mm_toxe=0.71890151287962623 mm_voff=-0.43382197592823457 mm_nfactor=1.4813930200080687
XNb23 ob23 in 0 0 sky130_fd_pr__nfet_01v8 w=2.0 l=0.15 mm_vth0=-0.045833730442345955 mm_toxe=0.28370179132491102 mm_voff=-1.5376108098077024 mm_nfactor=-0.69147578364530982
XPb24 ob24 in vdd vdd sky130_fd_pr__pfet_01v8 w=0.42 l=4.0 mm_vth0=0.52667693957284423 mm_toxe=0.12237099762091706 mm_voff=0.3649594150727557 mm_nfactor=1.0491493074099305
XNb24 ob24 in 0 0 sky130_fd_pr__nfet_01v8 w=2.0 l=0.15 mm_vth0=1.1118294807574047 mm_toxe=-0.36864760352748649 mm_voff=-0.948491799019194 mm_nfactor=-0.90072244569365356
XPb25 ob25 in vdd vdd sky130_fd_pr__pfet_01v8 w=0.42 l=4.0 mm_vth0=0.39700935393962467 mm_toxe=0.78271369751182218 mm_voff=0.023518868894752049 mm_nfactor=-1.7452255139808557
XNb25 ob25 in 0 0 sky130_fd_pr__nfet_01v8 w=2.0 l=0.15 mm_vth0=-1.3202012694801586 mm_toxe=0.6123311627102147 mm_voff=-0.25512770908381865 mm_nfactor=0.30631081160867485
XPb26 ob26 in vdd vdd sky130_fd_pr__pfet_01v8 w=0.42 l=4.0 mm_vth0=-1.6755762018976466 mm_toxe=-0.39470651457264638 mm_voff=0.62966085806559369 mm_nfactor=0.25159099635449983
XNb26 ob26 in 0 0 sky130_fd_pr__nfet_01v8 w=2.0 l=0.15 mm_vth0=1.6203434222989157 mm_toxe=0.8008795463266849 mm_voff=-0.54286720497544394 mm_nfactor=-1.8645131643620152
XPb27 ob27 in vdd vdd sky130_fd_pr__pfet_01v8 w=0.42 l=4.0 mm_vth0=0.1944892519268287 mm_toxe=-0.56227050637438059 mm_voff=-0.027787277623398405 mm_nfactor=0.71490538071464971
XNb27 ob27 in 0 0 sky130_fd_pr__nfet_01v8 w=2.0 l=0.15 mm_vth0=-0.27448574829162314 mm_toxe=0.25520751536493536 mm_voff=0.33628808625063278 mm_nfactor=1.7877890082398018
XPb28 ob28 in vdd vdd sky130_fd_pr__pfet_01v8 w=0.42 l=4.0 mm_vth0=0.36849771798493752 mm_toxe=0.10891658984813019 mm_voff=-0.24247818190074338 mm_nfactor=-0.66367531286236148
XNb28 ob28 in 0 0 sky130_fd_pr__nfet_01v8 w=2.0 l=0.15 mm_vth0=-0.99375828455997472 mm_toxe=-0.076251151608877937 mm_voff=0.23733201473980162 mm_nfactor=-0.33406739316915063
XPb29 ob29 in vdd vdd sky130_fd_pr__pfet_01v8 w=0.42 l=4.0 mm_vth0=0.2952408555482724 mm_toxe=-0.036156443733628488 mm_voff=0.17864633653189732 mm_nfactor=-1.0178123339513276
XNb29 ob29 in 0 0 sky130_fd_pr__nfet_01v8 w=2.0 l=0.15 mm_vth0=0.37201474146371172 mm_toxe=0.23628884896946153 mm_voff=-0.035903261209249047 mm_nfactor=0.46346368520612946
XPb210 ob210 in vdd vdd sky130_fd_pr__pfet_01v8 w=0.42 l=4.0 mm_vth0=0.6206795076194066 mm_toxe=-0.23166276613477152 mm_voff=-1.2368934800916271 mm_nfactor=1.1658475645237145
XNb210 ob210 in 0 0 sky130_fd_pr__nfet_01v8 w=2.0 l=0.15 mm_vth0=-1.2672919099492757 mm_toxe=-0.51116424512248193 mm_voff=0.35385334299472304 mm_nfactor=1.1071023023573401
XPb211 ob211 in vdd vdd sky130_fd_pr__pfet_01v8 w=0.42 l=4.0 mm_vth0=-0.24924486652665476 mm_toxe=-0.4115763319576739 mm_voff=0.28360155386552294 mm_nfactor=-0.24989834947046352
XNb211 ob211 in 0 0 sky130_fd_pr__nfet_01v8 w=2.0 l=0.15 mm_vth0=-0.10360361073707183 mm_toxe=0.22420974655429363 mm_voff=0.296819816289914 mm_nfactor=-3.8673797956267855
XPb212 ob212 in vdd vdd sky130_fd_pr__pfet_01v8 w=0.42 l=4.0 mm_vth0=0.46863528743215355 mm_toxe=0.5927246744223319 mm_voff=-0.46730796272856462 mm_nfactor=-0.89122657811786843
XNb212 ob212 in 0 0 sky130_fd_pr__nfet_01v8 w=2.0 l=0.15 mm_vth0=0.5771807885489274 mm_toxe=0.20679521211787649 mm_voff=-1.1630005139428097 mm_nfactor=0.16093511300461033
XPb213 ob213 in vdd vdd sky130_fd_pr__pfet_01v8 w=0.42 l=4.0 mm_vth0=2.152176154227496 mm_toxe=2.2602773307232886 mm_voff=0.89202978234596286 mm_nfactor=-1.1615572791478386
XNb213 ob213 in 0 0 sky130_fd_pr__nfet_01v8 w=2.0 l=0.15 mm_vth0=1.3399101000632185 mm_toxe=-0.67399350823693704 mm_voff=0.20552355255617377 mm_nfactor=-0.116745497708033
XPb214 ob214 in vdd vdd sky130_fd_pr__pfet_01v8 w=0.42 l=4.0 mm_vth0=1.3782903694924971 mm_toxe=0.84752597333337398 mm_voff=0.61081174343202471 mm_nfactor=-0.16660158321925933
XNb214 ob214 in 0 0 sky130_fd_pr__nfet_01v8 w=2.0 l=0.15 mm_vth0=-0.49477521600814495 mm_toxe=-1.4667596292901406 mm_voff=-0.70104937083881325 mm_nfactor=-1.6051347730929963
XPb215 ob215 in vdd vdd sky130_fd_pr__pfet_01v8 w=0.42 l=4.0 mm_vth0=-1.2863724146729396 mm_toxe=-0.66738383177052707 mm_voff=-0.40825798342913799 mm_nfactor=-0.017905034032639752
XNb215 ob215 in 0 0 sky130_fd_pr__nfet_01v8 w=2.0 l=0.15 mm_vth0=-1.1838310374604819 mm_toxe=0.012476593325149185 mm_voff=-0.99432542387189538 mm_nfactor=-1.4849461506550059
XPb216 ob216 in vdd vdd sky130_fd_pr__pfet_01v8 w=0.42 l=4.0 mm_vth0=0.19792543722617789 mm_toxe=-0.75527302657744888 mm_voff=-0.47330185261158936 mm_nfactor=-2.2139371434668149
XNb216 ob216 in 0 0 sky130_fd_pr__nfet_01v8 w=2.0 l=0.15 mm_vth0=0.79769226250018743 mm_toxe=-1.4418754771434372 mm_voff=0.42583141277652725 mm_nfactor=0.25970278861356477
XPb217 ob217 in vdd vdd sky130_fd_pr__pfet_01v8 w=0.42 l=4.0 mm_vth0=1.2964511969577848 mm_toxe=-0.95662253427798072 mm_voff=2.7830875047850108 mm_nfactor=-0.4422347689824323
XNb217 ob217 in 0 0 sky130_fd_pr__nfet_01v8 w=2.0 l=0.15 mm_vth0=1.5188508953926581 mm_toxe=1.221934897972309 mm_voff=1.0567181241974879 mm_nfactor=0.4208440972431598
XPb218 ob218 in vdd vdd sky130_fd_pr__pfet_01v8 w=0.42 l=4.0 mm_vth0=-0.17610388865189885 mm_toxe=-0.16838530573711788 mm_voff=-0.19750637063909526 mm_nfactor=-0.20299119992946071
XNb218 ob218 in 0 0 sky130_fd_pr__nfet_01v8 w=2.0 l=0.15 mm_vth0=-0.10005639606466857 mm_toxe=2.4129312316808513 mm_voff=0.34271895812694231 mm_nfactor=-0.83807618180384857
XPb219 ob219 in vdd vdd sky130_fd_pr__pfet_01v8 w=0.42 l=4.0 mm_vth0=0.020342470618694892 mm_toxe=0.22546757961187056 mm_voff=-0.37939801651160865 mm_nfactor=1.6313373146510743
XNb219 ob219 in 0 0 sky130_fd_pr__nfet_01v8 w=2.0 l=0.15 mm_vth0=1.4366225112225421 mm_toxe=0.62125923512758674 mm_voff=0.87213305448300704 mm_nfactor=-1.1787684600486406
XPb220 ob220 in vdd vdd sky130_fd_pr__pfet_01v8 w=0.42 l=4.0 mm_vth0=2.3972857398460374 mm_toxe=-0.64908916594280119 mm_voff=-2.1424907154129165 mm_nfactor=0.28126967066705544
XNb220 ob220 in 0 0 sky130_fd_pr__nfet_01v8 w=2.0 l=0.15 mm_vth0=0.71633374804605121 mm_toxe=0.79129454830952906 mm_voff=0.34656008736109994 mm_nfactor=-0.34594669670675232
.control
set filetype=binary
dc VIN 0.40 0.75 2e-5
write inv.raw v(ou0) v(ou1) v(ou2) v(ou3) v(ou4) v(ou5) v(ou6) v(ou7) v(ou8) v(ou9) v(ou10) v(ou11) v(ou12) v(ou13) v(ou14) v(ou15) v(ou16) v(ou17) v(ou18) v(ou19) v(ou20) v(ob11) v(ob12) v(ob13) v(ob14) v(ob15) v(ob16) v(ob17) v(ob18) v(ob19) v(ob110) v(ob111) v(ob112) v(ob113) v(ob114) v(ob115) v(ob116) v(ob117) v(ob118) v(ob119) v(ob120) v(ob21) v(ob22) v(ob23) v(ob24) v(ob25) v(ob26) v(ob27) v(ob28) v(ob29) v(ob210) v(ob211) v(ob212) v(ob213) v(ob214) v(ob215) v(ob216) v(ob217) v(ob218) v(ob219) v(ob220)
quit
.endc
.end
