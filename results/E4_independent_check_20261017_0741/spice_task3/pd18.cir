* E4 independent: pull-downs, V_DS = 1.8 V
.include "/home/claude/PCM_aCAM/third_party/sky130_fd_pr_subset_e3b/sky130_subset_tt.lib.spice"
.options reltol=1e-7 abstol=1e-16 vntol=1e-10

VG g 0 0.5
VDlo0 dlo0 0 1.8
Xlo0 dlo0 g 0 0 sky130_fd_pr__nfet_01v8_lvt w=0.42 l=0.15
VDlo1 dlo1 0 1.8
Xlo1 dlo1 g 0 0 sky130_fd_pr__nfet_01v8_lvt w=0.42 l=0.15 mm_vth0=0.21824786424978634 mm_toxe=-0.76742475860345749 mm_voff=0.54244990000394711 mm_nfactor=0.94524637971745007
VDlo2 dlo2 0 1.8
Xlo2 dlo2 g 0 0 sky130_fd_pr__nfet_01v8_lvt w=0.42 l=0.15 mm_vth0=-0.4836362596740939 mm_toxe=1.3804579769919019 mm_voff=0.27702460722800681 mm_nfactor=-0.15974028825293884
VDlo3 dlo3 0 1.8
Xlo3 dlo3 g 0 0 sky130_fd_pr__nfet_01v8_lvt w=0.42 l=0.15 mm_vth0=0.38308296555114746 mm_toxe=-1.8827258134273328 mm_voff=-0.20973707643475278 mm_nfactor=-0.057275972044258126
VDlo4 dlo4 0 1.8
Xlo4 dlo4 g 0 0 sky130_fd_pr__nfet_01v8_lvt w=0.42 l=0.15 mm_vth0=0.3223609400603144 mm_toxe=0.33313200235170348 mm_voff=1.2196047102620928 mm_nfactor=0.78029695385820275
VDlo5 dlo5 0 1.8
Xlo5 dlo5 g 0 0 sky130_fd_pr__nfet_01v8_lvt w=0.42 l=0.15 mm_vth0=0.6833813179455146 mm_toxe=-0.36202417162622025 mm_voff=0.49769646218410091 mm_nfactor=-0.3106810260015464
VDlo6 dlo6 0 1.8
Xlo6 dlo6 g 0 0 sky130_fd_pr__nfet_01v8_lvt w=0.42 l=0.15 mm_vth0=0.14394516749464492 mm_toxe=-0.90782411520287842 mm_voff=-0.31084031582907123 mm_nfactor=0.55216307441700008
VDlo7 dlo7 0 1.8
Xlo7 dlo7 g 0 0 sky130_fd_pr__nfet_01v8_lvt w=0.42 l=0.15 mm_vth0=-0.22242185116468705 mm_toxe=0.80393518372510486 mm_voff=2.7651693347415058 mm_nfactor=-0.53479126744249639
VDlo8 dlo8 0 1.8
Xlo8 dlo8 g 0 0 sky130_fd_pr__nfet_01v8_lvt w=0.42 l=0.15 mm_vth0=0.31203424794959184 mm_toxe=0.60841041590155664 mm_voff=-2.5095709648408535 mm_nfactor=-1.714654052891367
VDlo9 dlo9 0 1.8
Xlo9 dlo9 g 0 0 sky130_fd_pr__nfet_01v8_lvt w=0.42 l=0.15 mm_vth0=-0.17119068200010293 mm_toxe=1.8212903123609967 mm_voff=-1.0306319242851909 mm_nfactor=-0.76901708092977095
VDlo10 dlo10 0 1.8
Xlo10 dlo10 g 0 0 sky130_fd_pr__nfet_01v8_lvt w=0.42 l=0.15 mm_vth0=-0.21717457045767991 mm_toxe=-0.53779929352583067 mm_voff=1.3803303873461286 mm_nfactor=0.049769967691099343
VDlo11 dlo11 0 1.8
Xlo11 dlo11 g 0 0 sky130_fd_pr__nfet_01v8_lvt w=0.42 l=0.15 mm_vth0=0.50622265981830883 mm_toxe=2.1346501531211364 mm_voff=-0.378573971310669 mm_nfactor=-0.58291727555209838
VDlo12 dlo12 0 1.8
Xlo12 dlo12 g 0 0 sky130_fd_pr__nfet_01v8_lvt w=0.42 l=0.15 mm_vth0=-1.7997153425078127 mm_toxe=1.7002124266407148 mm_voff=0.67734058301221167 mm_nfactor=-0.63591853143253252
VDlo13 dlo13 0 1.8
Xlo13 dlo13 g 0 0 sky130_fd_pr__nfet_01v8_lvt w=0.42 l=0.15 mm_vth0=0.79200625396114877 mm_toxe=-0.08738784962675708 mm_voff=-0.17256627269663796 mm_nfactor=0.68092030182522689
VDlo14 dlo14 0 1.8
Xlo14 dlo14 g 0 0 sky130_fd_pr__nfet_01v8_lvt w=0.42 l=0.15 mm_vth0=0.19972947867963947 mm_toxe=-0.85962239658356476 mm_voff=1.1893159886093767 mm_nfactor=0.12678935384363019
VDlo15 dlo15 0 1.8
Xlo15 dlo15 g 0 0 sky130_fd_pr__nfet_01v8_lvt w=0.42 l=0.15 mm_vth0=0.88228655669782896 mm_toxe=0.58811687587897832 mm_voff=1.5233432815768111 mm_nfactor=0.52037371105929153
VDlo16 dlo16 0 1.8
Xlo16 dlo16 g 0 0 sky130_fd_pr__nfet_01v8_lvt w=0.42 l=0.15 mm_vth0=-1.1691588585290145 mm_toxe=0.13418027774133576 mm_voff=0.27895108266823515 mm_nfactor=0.50597901985011295
VDlo17 dlo17 0 1.8
Xlo17 dlo17 g 0 0 sky130_fd_pr__nfet_01v8_lvt w=0.42 l=0.15 mm_vth0=-0.17114150261605737 mm_toxe=-0.32820299203258091 mm_voff=-1.0876286192297635 mm_nfactor=-2.3030736467940054
VDlo18 dlo18 0 1.8
Xlo18 dlo18 g 0 0 sky130_fd_pr__nfet_01v8_lvt w=0.42 l=0.15 mm_vth0=-0.42668932644666774 mm_toxe=0.10754980110873696 mm_voff=-0.51223655989414685 mm_nfactor=-0.34497006946371639
VDlo19 dlo19 0 1.8
Xlo19 dlo19 g 0 0 sky130_fd_pr__nfet_01v8_lvt w=0.42 l=0.15 mm_vth0=-0.00063392222522675183 mm_toxe=1.28728814409105 mm_voff=-0.079957587003067862 mm_nfactor=-1.1428023977606454
VDlo20 dlo20 0 1.8
Xlo20 dlo20 g 0 0 sky130_fd_pr__nfet_01v8_lvt w=0.42 l=0.15 mm_vth0=1.3014953851136082 mm_toxe=-0.0074628515845403323 mm_voff=0.89264411963494317 mm_nfactor=1.5685264327989237
VDhi1 dhi1 0 1.8
Xhi1 dhi1 g 0 0 sky130_fd_pr__nfet_01v8_lvt w=0.42 l=0.15 mm_vth0=-2.0117153265441443 mm_toxe=-0.2060488140752488 mm_voff=0.61463860221412148 mm_nfactor=2.6578778085767758
VDhi2 dhi2 0 1.8
Xhi2 dhi2 g 0 0 sky130_fd_pr__nfet_01v8_lvt w=0.42 l=0.15 mm_vth0=0.65477610337947734 mm_toxe=-1.2168109553395294 mm_voff=0.83454925300252913 mm_nfactor=-0.80852470173344915
VDhi3 dhi3 0 1.8
Xhi3 dhi3 g 0 0 sky130_fd_pr__nfet_01v8_lvt w=0.42 l=0.15 mm_vth0=0.096351157463182832 mm_toxe=2.1398206633424812 mm_voff=-0.31620126862529968 mm_nfactor=1.0044867525568673
VDhi4 dhi4 0 1.8
Xhi4 dhi4 g 0 0 sky130_fd_pr__nfet_01v8_lvt w=0.42 l=0.15 mm_vth0=1.6142335232480651 mm_toxe=1.8545045284313599 mm_voff=-1.3857865866927257 mm_nfactor=-0.79520611712819622
VDhi5 dhi5 0 1.8
Xhi5 dhi5 g 0 0 sky130_fd_pr__nfet_01v8_lvt w=0.42 l=0.15 mm_vth0=0.42848954333484418 mm_toxe=-0.37313375190537151 mm_voff=0.87563466833417936 mm_nfactor=1.2950839998517778
VDhi6 dhi6 0 1.8
Xhi6 dhi6 g 0 0 sky130_fd_pr__nfet_01v8_lvt w=0.42 l=0.15 mm_vth0=0.1969134263334795 mm_toxe=0.66486344163449795 mm_voff=0.6348991146797931 mm_nfactor=0.81397355741992716
VDhi7 dhi7 0 1.8
Xhi7 dhi7 g 0 0 sky130_fd_pr__nfet_01v8_lvt w=0.42 l=0.15 mm_vth0=0.30879663473068625 mm_toxe=-0.8627867431913947 mm_voff=0.89141638543131774 mm_nfactor=0.58016711173772173
VDhi8 dhi8 0 1.8
Xhi8 dhi8 g 0 0 sky130_fd_pr__nfet_01v8_lvt w=0.42 l=0.15 mm_vth0=-0.1639213451559039 mm_toxe=-0.70127047176671464 mm_voff=0.51398008931729455 mm_nfactor=0.25083231884850171
VDhi9 dhi9 0 1.8
Xhi9 dhi9 g 0 0 sky130_fd_pr__nfet_01v8_lvt w=0.42 l=0.15 mm_vth0=-0.18223077485392214 mm_toxe=1.6584919783400445 mm_voff=-0.52906364658715677 mm_nfactor=-0.53329852628633934
VDhi10 dhi10 0 1.8
Xhi10 dhi10 g 0 0 sky130_fd_pr__nfet_01v8_lvt w=0.42 l=0.15 mm_vth0=-0.080312355943377975 mm_toxe=-0.18613427456344406 mm_voff=1.325820886560972 mm_nfactor=0.3228752368549711
VDhi11 dhi11 0 1.8
Xhi11 dhi11 g 0 0 sky130_fd_pr__nfet_01v8_lvt w=0.42 l=0.15 mm_vth0=0.68321401810776228 mm_toxe=-0.51894897278207175 mm_voff=-0.93291337434234267 mm_nfactor=-1.2759241226351148
VDhi12 dhi12 0 1.8
Xhi12 dhi12 g 0 0 sky130_fd_pr__nfet_01v8_lvt w=0.42 l=0.15 mm_vth0=-0.018108656179818699 mm_toxe=0.075502226927784272 mm_voff=0.093493163564335235 mm_nfactor=0.089455397757557911
VDhi13 dhi13 0 1.8
Xhi13 dhi13 g 0 0 sky130_fd_pr__nfet_01v8_lvt w=0.42 l=0.15 mm_vth0=-0.089962000506751974 mm_toxe=0.66597714677276254 mm_voff=0.85473382813323673 mm_nfactor=-0.61438878010950337
VDhi14 dhi14 0 1.8
Xhi14 dhi14 g 0 0 sky130_fd_pr__nfet_01v8_lvt w=0.42 l=0.15 mm_vth0=-0.986350919487886 mm_toxe=0.26776411569271724 mm_voff=-1.5482597161270932 mm_nfactor=-1.0278213207008728
VDhi15 dhi15 0 1.8
Xhi15 dhi15 g 0 0 sky130_fd_pr__nfet_01v8_lvt w=0.42 l=0.15 mm_vth0=-0.053257202568443726 mm_toxe=-0.025364883112708018 mm_voff=1.2680475846802153 mm_nfactor=-0.34623530772934308
VDhi16 dhi16 0 1.8
Xhi16 dhi16 g 0 0 sky130_fd_pr__nfet_01v8_lvt w=0.42 l=0.15 mm_vth0=-0.85646491426549065 mm_toxe=0.10797908243582113 mm_voff=-0.47429412871952931 mm_nfactor=-0.016439055345849836
VDhi17 dhi17 0 1.8
Xhi17 dhi17 g 0 0 sky130_fd_pr__nfet_01v8_lvt w=0.42 l=0.15 mm_vth0=0.82846773925005401 mm_toxe=0.73153872738760084 mm_voff=-0.7979888893553716 mm_nfactor=-0.35067911596692541
VDhi18 dhi18 0 1.8
Xhi18 dhi18 g 0 0 sky130_fd_pr__nfet_01v8_lvt w=0.42 l=0.15 mm_vth0=1.1189468078258025 mm_toxe=0.27836805832078987 mm_voff=1.1424311074774633 mm_nfactor=-0.54611682479402957
VDhi19 dhi19 0 1.8
Xhi19 dhi19 g 0 0 sky130_fd_pr__nfet_01v8_lvt w=0.42 l=0.15 mm_vth0=0.19372708410066622 mm_toxe=2.1754510989940901 mm_voff=-0.11479803251122793 mm_nfactor=-1.110561628636447
VDhi20 dhi20 0 1.8
Xhi20 dhi20 g 0 0 sky130_fd_pr__nfet_01v8_lvt w=0.42 l=0.15 mm_vth0=-1.5484200271038973 mm_toxe=0.34505522065219923 mm_voff=-0.76471338527451271 mm_nfactor=0.21701536334780386
.control
set filetype=binary
dc VG 0.3 0.8 0.0001
write pd18.raw i(VDlo0) i(VDlo1) i(VDlo2) i(VDlo3) i(VDlo4) i(VDlo5) i(VDlo6) i(VDlo7) i(VDlo8) i(VDlo9) i(VDlo10) i(VDlo11) i(VDlo12) i(VDlo13) i(VDlo14) i(VDlo15) i(VDlo16) i(VDlo17) i(VDlo18) i(VDlo19) i(VDlo20) i(VDhi1) i(VDhi2) i(VDhi3) i(VDhi4) i(VDhi5) i(VDhi6) i(VDhi7) i(VDhi8) i(VDhi9) i(VDhi10) i(VDhi11) i(VDhi12) i(VDhi13) i(VDhi14) i(VDhi15) i(VDhi16) i(VDhi17) i(VDhi18) i(VDhi19) i(VDhi20)
quit
.endc
.end
