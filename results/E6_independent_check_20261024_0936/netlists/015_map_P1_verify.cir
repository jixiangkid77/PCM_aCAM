* E6 independent check: map_P1_verify
.include "/home/claude/PCM_aCAM/third_party/sky130_fd_pr_subset_e3b/sky130_subset_tt.lib.spice"
.temp 27
.options reltol=1e-6 vntol=1e-9 abstol=1e-15
vd0 d0 0 0.5262214733902646
vg0 g0 0 0.6793037310635283
xdv0 d0 g0 0 0 sky130_fd_pr__nfet_01v8 w=0.42 l=0.15
vd1 d1 0 0.5262214733902646
vg1 g1 0 0.6795805910304514
xdv1 d1 g1 0 0 sky130_fd_pr__nfet_01v8 w=0.42 l=0.15
vd2 d2 0 0.5262214733902646
vg2 g2 0 0.6798561807776712
xdv2 d2 g2 0 0 sky130_fd_pr__nfet_01v8 w=0.42 l=0.15
vd3 d3 0 0.5262214733902646
vg3 g3 0 0.7414969413070084
xdv3 d3 g3 0 0 sky130_fd_pr__nfet_01v8 w=0.42 l=0.15
vd4 d4 0 0.5262214733902646
vg4 g4 0 0.7782260202853841
xdv4 d4 g4 0 0 sky130_fd_pr__nfet_01v8 w=0.42 l=0.15
vd5 d5 0 0.5262214733902646
vg5 g5 0 0.7986150966138341
xdv5 d5 g5 0 0 sky130_fd_pr__nfet_01v8 w=0.42 l=0.15
vd6 d6 0 0.5262214733902646
vg6 g6 0 0.8178822776445098
xdv6 d6 g6 0 0 sky130_fd_pr__nfet_01v8 w=0.42 l=0.15
vd7 d7 0 0.5262214733902646
vg7 g7 0 0.8179294804962679
xdv7 d7 g7 0 0 sky130_fd_pr__nfet_01v8 w=0.42 l=0.15
vd8 d8 0 0.5262214733902646
vg8 g8 0 0.8179766636957145
xdv8 d8 g8 0 0 sky130_fd_pr__nfet_01v8 w=0.42 l=0.15
vd9 d9 0 0.5262214733902646
vg9 g9 0 0.6447047584369856
xdv9 d9 g9 0 0 sky130_fd_pr__nfet_01v8 w=0.42 l=0.15
vd10 d10 0 0.5262214733902646
vg10 g10 0 0.6449583443659433
xdv10 d10 g10 0 0 sky130_fd_pr__nfet_01v8 w=0.42 l=0.15
vd11 d11 0 0.5262214733902646
vg11 g11 0 0.6452107343090489
xdv11 d11 g11 0 0 sky130_fd_pr__nfet_01v8 w=0.42 l=0.15
vd12 d12 0 0.5262214733902646
vg12 g12 0 0.7008629682488615
xdv12 d12 g12 0 0 sky130_fd_pr__nfet_01v8 w=0.42 l=0.15
vd13 d13 0 0.5262214733902646
vg13 g13 0 0.733180480723413
xdv13 d13 g13 0 0 sky130_fd_pr__nfet_01v8 w=0.42 l=0.15
vd14 d14 0 0.5262214733902646
vg14 g14 0 0.7507572867279034
xdv14 d14 g14 0 0 sky130_fd_pr__nfet_01v8 w=0.42 l=0.15
vd15 d15 0 0.5262214733902646
vg15 g15 0 0.767072635508876
xdv15 d15 g15 0 0 sky130_fd_pr__nfet_01v8 w=0.42 l=0.15
vd16 d16 0 0.5262214733902646
vg16 g16 0 0.7671122219971417
xdv16 d16 g16 0 0 sky130_fd_pr__nfet_01v8 w=0.42 l=0.15
vd17 d17 0 0.5262214733902646
vg17 g17 0 0.7671517900516601
xdv17 d17 g17 0 0 sky130_fd_pr__nfet_01v8 w=0.42 l=0.15
vu0 du0 0 0.5703217764363896
vgu0 gu0 0 0.6795805910304514
xdu0 du0 gu0 0 0 sky130_fd_pr__nfet_01v8 w=0.42 l=0.15
vu1 du1 0 0.5703217764363896
vgu1 gu1 0 0.7782260202853841
xdu1 du1 gu1 0 0 sky130_fd_pr__nfet_01v8 w=0.42 l=0.15
vu2 du2 0 0.5703217764363896
vgu2 gu2 0 0.8179294804962679
xdu2 du2 gu2 0 0 sky130_fd_pr__nfet_01v8 w=0.42 l=0.15
.control
set filetype=binary
op
write 015_map_P1_verify_o.raw all
quit
.endc
.end
