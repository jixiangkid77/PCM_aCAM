* E6 independent check: tran_s02_half_step
.include "/home/claude/PCM_aCAM/third_party/sky130_fd_pr_subset_e3b/sky130_subset_tt.lib.spice"
.temp 27
.options reltol=1e-6 vntol=1e-9 abstol=1e-15
vsl_t sl_t 0 0.7262214733902645
r_t sl_t n_t 804916.898823098
xdiv_t n_t dl_t 0 0 sky130_fd_pr__nfet_01v8 w=0.42 l=0.15
vdl_t dl_t 0 pwl(0 0.6449583443659433 1e-09 0.6449583443659433 1.1000000000000001e-09 0.6449583443659433 1.515e-07 0.6449583443659433)
vml_t ml_t 0 1.8
xpd_t ml_t n_t 0 0 sky130_fd_pr__nfet_01v8_lvt w=0.42 l=0.15
cpar_t n_t 0 5e-16
.control
set filetype=binary
tran 5e-12 1.5e-07 0 1e-11
write 030_tran_s02_half_step_tr.raw v(dl_t) v(n_t)
quit
.endc
.end
