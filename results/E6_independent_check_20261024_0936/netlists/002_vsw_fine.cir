* E6 independent check: vsw_fine
.include "/home/claude/PCM_aCAM/third_party/sky130_fd_pr_subset_e3b/sky130_subset_tt.lib.spice"
.temp 27
.options reltol=1e-6 vntol=1e-9 abstol=1e-15
vd d 0 1.8
vg g 0 0
xpd d g 0 0 sky130_fd_pr__nfet_01v8_lvt w=0.42 l=0.15
.control
set filetype=binary
dc vg 0.5259980000000001 0.527002 1e-06
write 002_vsw_fine_f0.raw all
quit
.endc
.end
