* E6 independent check: vx_cascade_fine
.include "/home/claude/PCM_aCAM/third_party/sky130_fd_pr_subset_e3b/sky130_subset_tt.lib.spice"
.temp 27
.options reltol=1e-6 vntol=1e-9 abstol=1e-15
vsup vs 0 1.8
vin in 0 0
xp_i1 mid in vs vs sky130_fd_pr__pfet_01v8 w=0.42 l=4.0
xn_i1 mid in 0 0 sky130_fd_pr__nfet_01v8 w=2.0 l=0.15
xp_i2 o mid vs vs sky130_fd_pr__pfet_01v8 w=0.42 l=4.0
xn_i2 o mid 0 0 sky130_fd_pr__nfet_01v8 w=2.0 l=0.15
vml ml 0 1.8
xpd ml o 0 0 sky130_fd_pr__nfet_01v8_lvt w=0.42 l=0.15
.control
set filetype=binary
dc vin 0.567998 0.5690019999999999 1e-06
write 009_vx_cascade_fine_f0.raw all
quit
.endc
.end
