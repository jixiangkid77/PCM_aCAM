* E4 independent: divider curves at V_DS = v_sp[k]
.include "/home/claude/PCM_aCAM/third_party/sky130_fd_pr_subset_e3b/sky130_subset_tt.lib.spice"
.options reltol=1e-7 abstol=1e-16 vntol=1e-10

VG g 0 0.5
VDP1L6T0 dP1L6T0 0 0.52622150704790538
XP1L6T0 dP1L6T0 g 0 0 sky130_fd_pr__nfet_01v8 w=0.42 l=0.15
VDP1L6T1 dP1L6T1 0 0.5243114083355549
XP1L6T1 dP1L6T1 g 0 0 sky130_fd_pr__nfet_01v8 w=0.42 l=0.15 mm_vth0=0.097680139937299945 mm_toxe=-1.4393141499490749 mm_voff=1.1113606002754957 mm_nfactor=1.5842082730411491
VDP1L6T2 dP1L6T2 0 0.52774770109028957
XP1L6T2 dP1L6T2 g 0 0 sky130_fd_pr__nfet_01v8 w=0.42 l=0.15 mm_vth0=-1.3305046791897501 mm_toxe=-0.43863776587843545 mm_voff=-0.84102857871489944 mm_nfactor=-1.7882199099357545
VDP1L6T3 dP1L6T3 0 0.51834030758681249
XP1L6T3 dP1L6T3 g 0 0 sky130_fd_pr__nfet_01v8 w=0.42 l=0.15 mm_vth0=0.31629075219629238 mm_toxe=0.6387119399198089 mm_voff=0.87385785907668923 mm_nfactor=0.50720722628317361
VDP1L6T4 dP1L6T4 0 0.53580123866531915
XP1L6T4 dP1L6T4 g 0 0 sky130_fd_pr__nfet_01v8 w=0.42 l=0.15 mm_vth0=0.17179760174173339 mm_toxe=0.80373976495683708 mm_voff=0.49455838038116956 mm_nfactor=-0.56665112624123681
VDP1L6T5 dP1L6T5 0 0.53749962835198917
XP1L6T5 dP1L6T5 g 0 0 sky130_fd_pr__nfet_01v8 w=0.42 l=0.15 mm_vth0=-1.3595669472940923 mm_toxe=0.43284032292335511 mm_voff=0.28154151059422472 mm_nfactor=1.0826068810802312
VDP1L6T6 dP1L6T6 0 0.52156637916445459
XP1L6T6 dP1L6T6 g 0 0 sky130_fd_pr__nfet_01v8 w=0.42 l=0.15 mm_vth0=-1.0907666472665607 mm_toxe=0.48859077547252444 mm_voff=1.3668413763283143 mm_nfactor=-1.2581768269679048
VDP1L6T7 dP1L6T7 0 0.52835250674413092
XP1L6T7 dP1L6T7 g 0 0 sky130_fd_pr__nfet_01v8 w=0.42 l=0.15 mm_vth0=-1.7581714568749409 mm_toxe=1.0598742996513923 mm_voff=0.30894180386660741 mm_nfactor=1.1088690220286819
VDP1L6T8 dP1L6T8 0 0.5379125699953804
XP1L6T8 dP1L6T8 g 0 0 sky130_fd_pr__nfet_01v8 w=0.42 l=0.15 mm_vth0=0.60581918278107438 mm_toxe=2.6312699557353691 mm_voff=-1.2217535352131479 mm_nfactor=0.19559725314787046
VDP1L6T9 dP1L6T9 0 0.53802815756964861
XP1L6T9 dP1L6T9 g 0 0 sky130_fd_pr__nfet_01v8 w=0.42 l=0.15 mm_vth0=-0.51855318134832673 mm_toxe=1.9071216919290566 mm_voff=-0.10714058964628236 mm_nfactor=-0.31670870376732996
VDP1L6T10 dP1L6T10 0 0.51712293601553028
XP1L6T10 dP1L6T10 g 0 0 sky130_fd_pr__nfet_01v8 w=0.42 l=0.15 mm_vth0=0.76922691258706832 mm_toxe=1.7369204977147841 mm_voff=1.8641996107056995 mm_nfactor=2.0188661103172802
VDP1L6T11 dP1L6T11 0 0.55490226476849169
XP1L6T11 dP1L6T11 g 0 0 sky130_fd_pr__nfet_01v8 w=0.42 l=0.15 mm_vth0=0.33169775401535501 mm_toxe=-0.22633645721529858 mm_voff=-0.05653586462063314 mm_nfactor=0.44008854281474069
VDP1L6T12 dP1L6T12 0 0.502879145312356
XP1L6T12 dP1L6T12 g 0 0 sky130_fd_pr__nfet_01v8 w=0.42 l=0.15 mm_vth0=0.60934306382100745 mm_toxe=-0.70387408040738064 mm_voff=0.11128689456235222 mm_nfactor=1.1013467811457016
VDP1L6T13 dP1L6T13 0 0.54210377960912504
XP1L6T13 dP1L6T13 g 0 0 sky130_fd_pr__nfet_01v8 w=0.42 l=0.15 mm_vth0=0.35983668561318338 mm_toxe=-0.23270666166059203 mm_voff=-0.21239074892742738 mm_nfactor=-0.60318163103787492
VDP1L6T14 dP1L6T14 0 0.52314364711917716
XP1L6T14 dP1L6T14 g 0 0 sky130_fd_pr__nfet_01v8 w=0.42 l=0.15 mm_vth0=-0.30272221900106416 mm_toxe=0.55785127764167364 mm_voff=-0.74633934544866232 mm_nfactor=0.97240254995846431
VDP1L6T15 dP1L6T15 0 0.5497159230337475
XP1L6T15 dP1L6T15 g 0 0 sky130_fd_pr__nfet_01v8 w=0.42 l=0.15 mm_vth0=0.783019088855755 mm_toxe=-0.94164209591172754 mm_voff=-1.1479168179989696 mm_nfactor=-0.65419650827423259
VDP1L6T16 dP1L6T16 0 0.50285794083657931
XP1L6T16 dP1L6T16 g 0 0 sky130_fd_pr__nfet_01v8 w=0.42 l=0.15 mm_vth0=-0.84563972821498934 mm_toxe=0.57450259711299489 mm_voff=0.24514085273086855 mm_nfactor=-0.24166001387957609
VDP1L6T17 dP1L6T17 0 0.51985903481556006
XP1L6T17 dP1L6T17 g 0 0 sky130_fd_pr__nfet_01v8 w=0.42 l=0.15 mm_vth0=-0.62949882529123891 mm_toxe=-1.6520279856452242 mm_voff=0.27906671776598962 mm_nfactor=-0.50831207161486702
VDP1L6T18 dP1L6T18 0 0.5181846998922397
XP1L6T18 dP1L6T18 g 0 0 sky130_fd_pr__nfet_01v8 w=0.42 l=0.15 mm_vth0=1.6915280305817311 mm_toxe=0.041585737628810161 mm_voff=0.015604300915189825 mm_nfactor=0.53774077800833964
VDP1L6T19 dP1L6T19 0 0.53709172052572685
XP1L6T19 dP1L6T19 g 0 0 sky130_fd_pr__nfet_01v8 w=0.42 l=0.15 mm_vth0=0.55818300184329861 mm_toxe=-2.1507801375746634 mm_voff=1.1574027907253517 mm_nfactor=0.88332401600097288
VDP1L6T20 dP1L6T20 0 0.55348461253244052
XP1L6T20 dP1L6T20 g 0 0 sky130_fd_pr__nfet_01v8 w=0.42 l=0.15 mm_vth0=1.9526750173175083 mm_toxe=-0.62628394698867973 mm_voff=-0.60185138026314 mm_nfactor=0.076878858361963717
VDP1UINV0 dP1UINV0 0 0.57032252167094422
XP1UINV0 dP1UINV0 g 0 0 sky130_fd_pr__nfet_01v8 w=0.42 l=0.15
VDP1UINV1 dP1UINV1 0 0.57675980830150608
XP1UINV1 dP1UINV1 g 0 0 sky130_fd_pr__nfet_01v8 w=0.42 l=0.15 mm_vth0=-0.88773512458630799 mm_toxe=-0.39924656948729736 mm_voff=0.77926301524802133 mm_nfactor=-0.78043630333179581
VDP1UINV2 dP1UINV2 0 0.55815957532695137
XP1UINV2 dP1UINV2 g 0 0 sky130_fd_pr__nfet_01v8 w=0.42 l=0.15 mm_vth0=0.35111898866177366 mm_toxe=0.89599892541952963 mm_voff=-0.87255527426677559 mm_nfactor=-0.18721948520022078
VDP1UINV3 dP1UINV3 0 0.56499423994357856
XP1UINV3 dP1UINV3 g 0 0 sky130_fd_pr__nfet_01v8 w=0.42 l=0.15 mm_vth0=0.85315000881976299 mm_toxe=-1.7085677404914099 mm_voff=-0.11024649720082505 mm_nfactor=0.039958299189271927
VDP1UINV4 dP1UINV4 0 0.55939484356560321
XP1UINV4 dP1UINV4 g 0 0 sky130_fd_pr__nfet_01v8 w=0.42 l=0.15 mm_vth0=2.0737399583666205 mm_toxe=-0.60492562699113206 mm_voff=-1.3592119105617231 mm_nfactor=0.07033625469900194
VDP1UINV5 dP1UINV5 0 0.57958002455985536
XP1UINV5 dP1UINV5 g 0 0 sky130_fd_pr__nfet_01v8 w=0.42 l=0.15 mm_vth0=-2.2468112208569702 mm_toxe=-0.084956361703443548 mm_voff=0.47057400015045509 mm_nfactor=-0.13384457968770347
VDP1UINV6 dP1UINV6 0 0.56921348464571386
XP1UINV6 dP1UINV6 g 0 0 sky130_fd_pr__nfet_01v8 w=0.42 l=0.15 mm_vth0=2.5370626116079453 mm_toxe=0.13984507802162138 mm_voff=1.9752094236686741 mm_nfactor=0.48502290510837881
VDP1UINV7 dP1UINV7 0 0.57553849931357681
XP1UINV7 dP1UINV7 g 0 0 sky130_fd_pr__nfet_01v8 w=0.42 l=0.15 mm_vth0=-1.5668477219007455 mm_toxe=0.24216200715868877 mm_voff=0.91244131621509961 mm_nfactor=0.30462746066603558
VDP1UINV8 dP1UINV8 0 0.54981943715377746
XP1UINV8 dP1UINV8 g 0 0 sky130_fd_pr__nfet_01v8 w=0.42 l=0.15 mm_vth0=-0.77755937556449961 mm_toxe=-0.35595014540943209 mm_voff=-0.0035122222377820308 mm_nfactor=0.93860715165783604
VDP1UINV9 dP1UINV9 0 0.56401569930877615
XP1UINV9 dP1UINV9 g 0 0 sky130_fd_pr__nfet_01v8 w=0.42 l=0.15 mm_vth0=0.095384346846875176 mm_toxe=-0.13934121821335177 mm_voff=0.86467824704383323 mm_nfactor=-0.13217135189930726
VDP1UINV10 dP1UINV10 0 0.57245790785747841
XP1UINV10 dP1UINV10 g 0 0 sky130_fd_pr__nfet_01v8 w=0.42 l=0.15 mm_vth0=0.64182782485085288 mm_toxe=0.27713041392641702 mm_voff=-0.32086408339906697 mm_nfactor=-0.078235501775404767
VDP1UINV11 dP1UINV11 0 0.57240031547184866
XP1UINV11 dP1UINV11 g 0 0 sky130_fd_pr__nfet_01v8 w=0.42 l=0.15 mm_vth0=-0.47045270147414253 mm_toxe=0.73807598367960026 mm_voff=-1.2178147029619493 mm_nfactor=0.085231450985077992
VDP1UINV12 dP1UINV12 0 0.57730971788602448
XP1UINV12 dP1UINV12 g 0 0 sky130_fd_pr__nfet_01v8 w=0.42 l=0.15 mm_vth0=1.4558043733747068 mm_toxe=-1.0696483799789376 mm_voff=-1.3485255678965566 mm_nfactor=-0.28139462918095132
VDP1UINV13 dP1UINV13 0 0.57677056679477334
XP1UINV13 dP1UINV13 g 0 0 sky130_fd_pr__nfet_01v8 w=0.42 l=0.15 mm_vth0=0.95456788900020328 mm_toxe=0.80319046908529168 mm_voff=-0.78666709203542728 mm_nfactor=1.001817938594008
VDP1UINV14 dP1UINV14 0 0.58760199398728463
XP1UINV14 dP1UINV14 g 0 0 sky130_fd_pr__nfet_01v8 w=0.42 l=0.15 mm_vth0=-1.5505541220472376 mm_toxe=-0.88514470474143958 mm_voff=-1.0423530149335276 mm_nfactor=-1.6140009416682795
VDP1UINV15 dP1UINV15 0 0.58023790336302306
XP1UINV15 dP1UINV15 g 0 0 sky130_fd_pr__nfet_01v8 w=0.42 l=0.15 mm_vth0=0.39640581378654105 mm_toxe=-1.3584341349230333 mm_voff=0.4314419656656821 mm_nfactor=0.19312389275516659
VDP1UINV16 dP1UINV16 0 0.57984338640626387
XP1UINV16 dP1UINV16 g 0 0 sky130_fd_pr__nfet_01v8 w=0.42 l=0.15 mm_vth0=0.86382102175685727 mm_toxe=-1.1438302586004523 mm_voff=0.91870056856819493 mm_nfactor=1.0636186024161094
VDP1UINV17 dP1UINV17 0 0.59952546908845983
XP1UINV17 dP1UINV17 g 0 0 sky130_fd_pr__nfet_01v8 w=0.42 l=0.15 mm_vth0=0.12174115924501284 mm_toxe=-0.016596614123211888 mm_voff=-0.85909489914437598 mm_nfactor=0.65737310221421663
VDP1UINV18 dP1UINV18 0 0.56639821391321499
XP1UINV18 dP1UINV18 g 0 0 sky130_fd_pr__nfet_01v8 w=0.42 l=0.15 mm_vth0=-0.50969114085647216 mm_toxe=-0.79627109244218175 mm_voff=0.3199800674338712 mm_nfactor=-1.4892278641255943
VDP1UINV19 dP1UINV19 0 0.55492832585122209
XP1UINV19 dP1UINV19 g 0 0 sky130_fd_pr__nfet_01v8 w=0.42 l=0.15 mm_vth0=1.9653149471533577 mm_toxe=1.2965999361981237 mm_voff=0.77009493467716095 mm_nfactor=0.4250268275471798
VDP1UINV20 dP1UINV20 0 0.57311127182647625
XP1UINV20 dP1UINV20 g 0 0 sky130_fd_pr__nfet_01v8 w=0.42 l=0.15 mm_vth0=-0.04870218080260983 mm_toxe=-0.51545831137254861 mm_voff=-0.12797929044695791 mm_nfactor=0.079009764675213146
VDP1LBUF0 dP1LBUF0 0 0.56842101015113955
XP1LBUF0 dP1LBUF0 g 0 0 sky130_fd_pr__nfet_01v8 w=0.42 l=0.15
VDP1LBUF1 dP1LBUF1 0 0.55193273255225606
XP1LBUF1 dP1LBUF1 g 0 0 sky130_fd_pr__nfet_01v8 w=0.42 l=0.15 mm_vth0=0.097680139937299945 mm_toxe=-1.4393141499490749 mm_voff=1.1113606002754957 mm_nfactor=1.5842082730411491
VDP1LBUF2 dP1LBUF2 0 0.56801179151070613
XP1LBUF2 dP1LBUF2 g 0 0 sky130_fd_pr__nfet_01v8 w=0.42 l=0.15 mm_vth0=-1.3305046791897501 mm_toxe=-0.43863776587843545 mm_voff=-0.84102857871489944 mm_nfactor=-1.7882199099357545
VDP1LBUF3 dP1LBUF3 0 0.57422681156706212
XP1LBUF3 dP1LBUF3 g 0 0 sky130_fd_pr__nfet_01v8 w=0.42 l=0.15 mm_vth0=0.31629075219629238 mm_toxe=0.6387119399198089 mm_voff=0.87385785907668923 mm_nfactor=0.50720722628317361
VDP1LBUF4 dP1LBUF4 0 0.54961286141682364
XP1LBUF4 dP1LBUF4 g 0 0 sky130_fd_pr__nfet_01v8 w=0.42 l=0.15 mm_vth0=0.17179760174173339 mm_toxe=0.80373976495683708 mm_voff=0.49455838038116956 mm_nfactor=-0.56665112624123681
VDP1LBUF5 dP1LBUF5 0 0.57573486439467347
XP1LBUF5 dP1LBUF5 g 0 0 sky130_fd_pr__nfet_01v8 w=0.42 l=0.15 mm_vth0=-1.3595669472940923 mm_toxe=0.43284032292335511 mm_voff=0.28154151059422472 mm_nfactor=1.0826068810802312
VDP1LBUF6 dP1LBUF6 0 0.57939188121067975
XP1LBUF6 dP1LBUF6 g 0 0 sky130_fd_pr__nfet_01v8 w=0.42 l=0.15 mm_vth0=-1.0907666472665607 mm_toxe=0.48859077547252444 mm_voff=1.3668413763283143 mm_nfactor=-1.2581768269679048
VDP1LBUF7 dP1LBUF7 0 0.58622034657941335
XP1LBUF7 dP1LBUF7 g 0 0 sky130_fd_pr__nfet_01v8 w=0.42 l=0.15 mm_vth0=-1.7581714568749409 mm_toxe=1.0598742996513923 mm_voff=0.30894180386660741 mm_nfactor=1.1088690220286819
VDP1LBUF8 dP1LBUF8 0 0.57003692931927907
XP1LBUF8 dP1LBUF8 g 0 0 sky130_fd_pr__nfet_01v8 w=0.42 l=0.15 mm_vth0=0.60581918278107438 mm_toxe=2.6312699557353691 mm_voff=-1.2217535352131479 mm_nfactor=0.19559725314787046
VDP1LBUF9 dP1LBUF9 0 0.55590119787613868
XP1LBUF9 dP1LBUF9 g 0 0 sky130_fd_pr__nfet_01v8 w=0.42 l=0.15 mm_vth0=-0.51855318134832673 mm_toxe=1.9071216919290566 mm_voff=-0.10714058964628236 mm_nfactor=-0.31670870376732996
VDP1LBUF10 dP1LBUF10 0 0.57733478835708263
XP1LBUF10 dP1LBUF10 g 0 0 sky130_fd_pr__nfet_01v8 w=0.42 l=0.15 mm_vth0=0.76922691258706832 mm_toxe=1.7369204977147841 mm_voff=1.8641996107056995 mm_nfactor=2.0188661103172802
VDP1LBUF11 dP1LBUF11 0 0.5673616074058826
XP1LBUF11 dP1LBUF11 g 0 0 sky130_fd_pr__nfet_01v8 w=0.42 l=0.15 mm_vth0=0.33169775401535501 mm_toxe=-0.22633645721529858 mm_voff=-0.05653586462063314 mm_nfactor=0.44008854281474069
VDP1LBUF12 dP1LBUF12 0 0.56520481803645617
XP1LBUF12 dP1LBUF12 g 0 0 sky130_fd_pr__nfet_01v8 w=0.42 l=0.15 mm_vth0=0.60934306382100745 mm_toxe=-0.70387408040738064 mm_voff=0.11128689456235222 mm_nfactor=1.1013467811457016
VDP1LBUF13 dP1LBUF13 0 0.56659585168217408
XP1LBUF13 dP1LBUF13 g 0 0 sky130_fd_pr__nfet_01v8 w=0.42 l=0.15 mm_vth0=0.35983668561318338 mm_toxe=-0.23270666166059203 mm_voff=-0.21239074892742738 mm_nfactor=-0.60318163103787492
VDP1LBUF14 dP1LBUF14 0 0.58735719484985305
XP1LBUF14 dP1LBUF14 g 0 0 sky130_fd_pr__nfet_01v8 w=0.42 l=0.15 mm_vth0=-0.30272221900106416 mm_toxe=0.55785127764167364 mm_voff=-0.74633934544866232 mm_nfactor=0.97240254995846431
VDP1LBUF15 dP1LBUF15 0 0.56361055675023419
XP1LBUF15 dP1LBUF15 g 0 0 sky130_fd_pr__nfet_01v8 w=0.42 l=0.15 mm_vth0=0.783019088855755 mm_toxe=-0.94164209591172754 mm_voff=-1.1479168179989696 mm_nfactor=-0.65419650827423259
VDP1LBUF16 dP1LBUF16 0 0.56837813747115584
XP1LBUF16 dP1LBUF16 g 0 0 sky130_fd_pr__nfet_01v8 w=0.42 l=0.15 mm_vth0=-0.84563972821498934 mm_toxe=0.57450259711299489 mm_voff=0.24514085273086855 mm_nfactor=-0.24166001387957609
VDP1LBUF17 dP1LBUF17 0 0.57454233619060957
XP1LBUF17 dP1LBUF17 g 0 0 sky130_fd_pr__nfet_01v8 w=0.42 l=0.15 mm_vth0=-0.62949882529123891 mm_toxe=-1.6520279856452242 mm_voff=0.27906671776598962 mm_nfactor=-0.50831207161486702
VDP1LBUF18 dP1LBUF18 0 0.57242404201471409
XP1LBUF18 dP1LBUF18 g 0 0 sky130_fd_pr__nfet_01v8 w=0.42 l=0.15 mm_vth0=1.6915280305817311 mm_toxe=0.041585737628810161 mm_voff=0.015604300915189825 mm_nfactor=0.53774077800833964
VDP1LBUF19 dP1LBUF19 0 0.57421387163654403
XP1LBUF19 dP1LBUF19 g 0 0 sky130_fd_pr__nfet_01v8 w=0.42 l=0.15 mm_vth0=0.55818300184329861 mm_toxe=-2.1507801375746634 mm_voff=1.1574027907253517 mm_nfactor=0.88332401600097288
VDP1LBUF20 dP1LBUF20 0 0.55141710691468937
XP1LBUF20 dP1LBUF20 g 0 0 sky130_fd_pr__nfet_01v8 w=0.42 l=0.15 mm_vth0=1.9526750173175083 mm_toxe=-0.62628394698867973 mm_voff=-0.60185138026314 mm_nfactor=0.076878858361963717
VDP3L6T0 dP3L6T0 0 0.52622150704790538
XP3L6T0 dP3L6T0 g 0 0 sky130_fd_pr__nfet_01v8 w=0.42 l=4.0
VDP3L6T1 dP3L6T1 0 0.5243114083355549
XP3L6T1 dP3L6T1 g 0 0 sky130_fd_pr__nfet_01v8 w=0.42 l=4.0 mm_vth0=0.097680139937299945 mm_toxe=-1.4393141499490749 mm_voff=1.1113606002754957 mm_nfactor=1.5842082730411491
VDP3L6T2 dP3L6T2 0 0.52774770109028957
XP3L6T2 dP3L6T2 g 0 0 sky130_fd_pr__nfet_01v8 w=0.42 l=4.0 mm_vth0=-1.3305046791897501 mm_toxe=-0.43863776587843545 mm_voff=-0.84102857871489944 mm_nfactor=-1.7882199099357545
VDP3L6T3 dP3L6T3 0 0.51834030758681249
XP3L6T3 dP3L6T3 g 0 0 sky130_fd_pr__nfet_01v8 w=0.42 l=4.0 mm_vth0=0.31629075219629238 mm_toxe=0.6387119399198089 mm_voff=0.87385785907668923 mm_nfactor=0.50720722628317361
VDP3L6T4 dP3L6T4 0 0.53580123866531915
XP3L6T4 dP3L6T4 g 0 0 sky130_fd_pr__nfet_01v8 w=0.42 l=4.0 mm_vth0=0.17179760174173339 mm_toxe=0.80373976495683708 mm_voff=0.49455838038116956 mm_nfactor=-0.56665112624123681
VDP3L6T5 dP3L6T5 0 0.53749962835198917
XP3L6T5 dP3L6T5 g 0 0 sky130_fd_pr__nfet_01v8 w=0.42 l=4.0 mm_vth0=-1.3595669472940923 mm_toxe=0.43284032292335511 mm_voff=0.28154151059422472 mm_nfactor=1.0826068810802312
VDP3L6T6 dP3L6T6 0 0.52156637916445459
XP3L6T6 dP3L6T6 g 0 0 sky130_fd_pr__nfet_01v8 w=0.42 l=4.0 mm_vth0=-1.0907666472665607 mm_toxe=0.48859077547252444 mm_voff=1.3668413763283143 mm_nfactor=-1.2581768269679048
VDP3L6T7 dP3L6T7 0 0.52835250674413092
XP3L6T7 dP3L6T7 g 0 0 sky130_fd_pr__nfet_01v8 w=0.42 l=4.0 mm_vth0=-1.7581714568749409 mm_toxe=1.0598742996513923 mm_voff=0.30894180386660741 mm_nfactor=1.1088690220286819
VDP3L6T8 dP3L6T8 0 0.5379125699953804
XP3L6T8 dP3L6T8 g 0 0 sky130_fd_pr__nfet_01v8 w=0.42 l=4.0 mm_vth0=0.60581918278107438 mm_toxe=2.6312699557353691 mm_voff=-1.2217535352131479 mm_nfactor=0.19559725314787046
VDP3L6T9 dP3L6T9 0 0.53802815756964861
XP3L6T9 dP3L6T9 g 0 0 sky130_fd_pr__nfet_01v8 w=0.42 l=4.0 mm_vth0=-0.51855318134832673 mm_toxe=1.9071216919290566 mm_voff=-0.10714058964628236 mm_nfactor=-0.31670870376732996
VDP3L6T10 dP3L6T10 0 0.51712293601553028
XP3L6T10 dP3L6T10 g 0 0 sky130_fd_pr__nfet_01v8 w=0.42 l=4.0 mm_vth0=0.76922691258706832 mm_toxe=1.7369204977147841 mm_voff=1.8641996107056995 mm_nfactor=2.0188661103172802
VDP3L6T11 dP3L6T11 0 0.55490226476849169
XP3L6T11 dP3L6T11 g 0 0 sky130_fd_pr__nfet_01v8 w=0.42 l=4.0 mm_vth0=0.33169775401535501 mm_toxe=-0.22633645721529858 mm_voff=-0.05653586462063314 mm_nfactor=0.44008854281474069
VDP3L6T12 dP3L6T12 0 0.502879145312356
XP3L6T12 dP3L6T12 g 0 0 sky130_fd_pr__nfet_01v8 w=0.42 l=4.0 mm_vth0=0.60934306382100745 mm_toxe=-0.70387408040738064 mm_voff=0.11128689456235222 mm_nfactor=1.1013467811457016
VDP3L6T13 dP3L6T13 0 0.54210377960912504
XP3L6T13 dP3L6T13 g 0 0 sky130_fd_pr__nfet_01v8 w=0.42 l=4.0 mm_vth0=0.35983668561318338 mm_toxe=-0.23270666166059203 mm_voff=-0.21239074892742738 mm_nfactor=-0.60318163103787492
VDP3L6T14 dP3L6T14 0 0.52314364711917716
XP3L6T14 dP3L6T14 g 0 0 sky130_fd_pr__nfet_01v8 w=0.42 l=4.0 mm_vth0=-0.30272221900106416 mm_toxe=0.55785127764167364 mm_voff=-0.74633934544866232 mm_nfactor=0.97240254995846431
VDP3L6T15 dP3L6T15 0 0.5497159230337475
XP3L6T15 dP3L6T15 g 0 0 sky130_fd_pr__nfet_01v8 w=0.42 l=4.0 mm_vth0=0.783019088855755 mm_toxe=-0.94164209591172754 mm_voff=-1.1479168179989696 mm_nfactor=-0.65419650827423259
VDP3L6T16 dP3L6T16 0 0.50285794083657931
XP3L6T16 dP3L6T16 g 0 0 sky130_fd_pr__nfet_01v8 w=0.42 l=4.0 mm_vth0=-0.84563972821498934 mm_toxe=0.57450259711299489 mm_voff=0.24514085273086855 mm_nfactor=-0.24166001387957609
VDP3L6T17 dP3L6T17 0 0.51985903481556006
XP3L6T17 dP3L6T17 g 0 0 sky130_fd_pr__nfet_01v8 w=0.42 l=4.0 mm_vth0=-0.62949882529123891 mm_toxe=-1.6520279856452242 mm_voff=0.27906671776598962 mm_nfactor=-0.50831207161486702
VDP3L6T18 dP3L6T18 0 0.5181846998922397
XP3L6T18 dP3L6T18 g 0 0 sky130_fd_pr__nfet_01v8 w=0.42 l=4.0 mm_vth0=1.6915280305817311 mm_toxe=0.041585737628810161 mm_voff=0.015604300915189825 mm_nfactor=0.53774077800833964
VDP3L6T19 dP3L6T19 0 0.53709172052572685
XP3L6T19 dP3L6T19 g 0 0 sky130_fd_pr__nfet_01v8 w=0.42 l=4.0 mm_vth0=0.55818300184329861 mm_toxe=-2.1507801375746634 mm_voff=1.1574027907253517 mm_nfactor=0.88332401600097288
VDP3L6T20 dP3L6T20 0 0.55348461253244052
XP3L6T20 dP3L6T20 g 0 0 sky130_fd_pr__nfet_01v8 w=0.42 l=4.0 mm_vth0=1.9526750173175083 mm_toxe=-0.62628394698867973 mm_voff=-0.60185138026314 mm_nfactor=0.076878858361963717
VDP3UINV0 dP3UINV0 0 0.57032252167094422
XP3UINV0 dP3UINV0 g 0 0 sky130_fd_pr__nfet_01v8 w=0.42 l=4.0
VDP3UINV1 dP3UINV1 0 0.57675980830150608
XP3UINV1 dP3UINV1 g 0 0 sky130_fd_pr__nfet_01v8 w=0.42 l=4.0 mm_vth0=-0.88773512458630799 mm_toxe=-0.39924656948729736 mm_voff=0.77926301524802133 mm_nfactor=-0.78043630333179581
VDP3UINV2 dP3UINV2 0 0.55815957532695137
XP3UINV2 dP3UINV2 g 0 0 sky130_fd_pr__nfet_01v8 w=0.42 l=4.0 mm_vth0=0.35111898866177366 mm_toxe=0.89599892541952963 mm_voff=-0.87255527426677559 mm_nfactor=-0.18721948520022078
VDP3UINV3 dP3UINV3 0 0.56499423994357856
XP3UINV3 dP3UINV3 g 0 0 sky130_fd_pr__nfet_01v8 w=0.42 l=4.0 mm_vth0=0.85315000881976299 mm_toxe=-1.7085677404914099 mm_voff=-0.11024649720082505 mm_nfactor=0.039958299189271927
VDP3UINV4 dP3UINV4 0 0.55939484356560321
XP3UINV4 dP3UINV4 g 0 0 sky130_fd_pr__nfet_01v8 w=0.42 l=4.0 mm_vth0=2.0737399583666205 mm_toxe=-0.60492562699113206 mm_voff=-1.3592119105617231 mm_nfactor=0.07033625469900194
VDP3UINV5 dP3UINV5 0 0.57958002455985536
XP3UINV5 dP3UINV5 g 0 0 sky130_fd_pr__nfet_01v8 w=0.42 l=4.0 mm_vth0=-2.2468112208569702 mm_toxe=-0.084956361703443548 mm_voff=0.47057400015045509 mm_nfactor=-0.13384457968770347
VDP3UINV6 dP3UINV6 0 0.56921348464571386
XP3UINV6 dP3UINV6 g 0 0 sky130_fd_pr__nfet_01v8 w=0.42 l=4.0 mm_vth0=2.5370626116079453 mm_toxe=0.13984507802162138 mm_voff=1.9752094236686741 mm_nfactor=0.48502290510837881
VDP3UINV7 dP3UINV7 0 0.57553849931357681
XP3UINV7 dP3UINV7 g 0 0 sky130_fd_pr__nfet_01v8 w=0.42 l=4.0 mm_vth0=-1.5668477219007455 mm_toxe=0.24216200715868877 mm_voff=0.91244131621509961 mm_nfactor=0.30462746066603558
VDP3UINV8 dP3UINV8 0 0.54981943715377746
XP3UINV8 dP3UINV8 g 0 0 sky130_fd_pr__nfet_01v8 w=0.42 l=4.0 mm_vth0=-0.77755937556449961 mm_toxe=-0.35595014540943209 mm_voff=-0.0035122222377820308 mm_nfactor=0.93860715165783604
VDP3UINV9 dP3UINV9 0 0.56401569930877615
XP3UINV9 dP3UINV9 g 0 0 sky130_fd_pr__nfet_01v8 w=0.42 l=4.0 mm_vth0=0.095384346846875176 mm_toxe=-0.13934121821335177 mm_voff=0.86467824704383323 mm_nfactor=-0.13217135189930726
VDP3UINV10 dP3UINV10 0 0.57245790785747841
XP3UINV10 dP3UINV10 g 0 0 sky130_fd_pr__nfet_01v8 w=0.42 l=4.0 mm_vth0=0.64182782485085288 mm_toxe=0.27713041392641702 mm_voff=-0.32086408339906697 mm_nfactor=-0.078235501775404767
VDP3UINV11 dP3UINV11 0 0.57240031547184866
XP3UINV11 dP3UINV11 g 0 0 sky130_fd_pr__nfet_01v8 w=0.42 l=4.0 mm_vth0=-0.47045270147414253 mm_toxe=0.73807598367960026 mm_voff=-1.2178147029619493 mm_nfactor=0.085231450985077992
VDP3UINV12 dP3UINV12 0 0.57730971788602448
XP3UINV12 dP3UINV12 g 0 0 sky130_fd_pr__nfet_01v8 w=0.42 l=4.0 mm_vth0=1.4558043733747068 mm_toxe=-1.0696483799789376 mm_voff=-1.3485255678965566 mm_nfactor=-0.28139462918095132
VDP3UINV13 dP3UINV13 0 0.57677056679477334
XP3UINV13 dP3UINV13 g 0 0 sky130_fd_pr__nfet_01v8 w=0.42 l=4.0 mm_vth0=0.95456788900020328 mm_toxe=0.80319046908529168 mm_voff=-0.78666709203542728 mm_nfactor=1.001817938594008
VDP3UINV14 dP3UINV14 0 0.58760199398728463
XP3UINV14 dP3UINV14 g 0 0 sky130_fd_pr__nfet_01v8 w=0.42 l=4.0 mm_vth0=-1.5505541220472376 mm_toxe=-0.88514470474143958 mm_voff=-1.0423530149335276 mm_nfactor=-1.6140009416682795
VDP3UINV15 dP3UINV15 0 0.58023790336302306
XP3UINV15 dP3UINV15 g 0 0 sky130_fd_pr__nfet_01v8 w=0.42 l=4.0 mm_vth0=0.39640581378654105 mm_toxe=-1.3584341349230333 mm_voff=0.4314419656656821 mm_nfactor=0.19312389275516659
VDP3UINV16 dP3UINV16 0 0.57984338640626387
XP3UINV16 dP3UINV16 g 0 0 sky130_fd_pr__nfet_01v8 w=0.42 l=4.0 mm_vth0=0.86382102175685727 mm_toxe=-1.1438302586004523 mm_voff=0.91870056856819493 mm_nfactor=1.0636186024161094
VDP3UINV17 dP3UINV17 0 0.59952546908845983
XP3UINV17 dP3UINV17 g 0 0 sky130_fd_pr__nfet_01v8 w=0.42 l=4.0 mm_vth0=0.12174115924501284 mm_toxe=-0.016596614123211888 mm_voff=-0.85909489914437598 mm_nfactor=0.65737310221421663
VDP3UINV18 dP3UINV18 0 0.56639821391321499
XP3UINV18 dP3UINV18 g 0 0 sky130_fd_pr__nfet_01v8 w=0.42 l=4.0 mm_vth0=-0.50969114085647216 mm_toxe=-0.79627109244218175 mm_voff=0.3199800674338712 mm_nfactor=-1.4892278641255943
VDP3UINV19 dP3UINV19 0 0.55492832585122209
XP3UINV19 dP3UINV19 g 0 0 sky130_fd_pr__nfet_01v8 w=0.42 l=4.0 mm_vth0=1.9653149471533577 mm_toxe=1.2965999361981237 mm_voff=0.77009493467716095 mm_nfactor=0.4250268275471798
VDP3UINV20 dP3UINV20 0 0.57311127182647625
XP3UINV20 dP3UINV20 g 0 0 sky130_fd_pr__nfet_01v8 w=0.42 l=4.0 mm_vth0=-0.04870218080260983 mm_toxe=-0.51545831137254861 mm_voff=-0.12797929044695791 mm_nfactor=0.079009764675213146
VDP3LBUF0 dP3LBUF0 0 0.56842101015113955
XP3LBUF0 dP3LBUF0 g 0 0 sky130_fd_pr__nfet_01v8 w=0.42 l=4.0
VDP3LBUF1 dP3LBUF1 0 0.55193273255225606
XP3LBUF1 dP3LBUF1 g 0 0 sky130_fd_pr__nfet_01v8 w=0.42 l=4.0 mm_vth0=0.097680139937299945 mm_toxe=-1.4393141499490749 mm_voff=1.1113606002754957 mm_nfactor=1.5842082730411491
VDP3LBUF2 dP3LBUF2 0 0.56801179151070613
XP3LBUF2 dP3LBUF2 g 0 0 sky130_fd_pr__nfet_01v8 w=0.42 l=4.0 mm_vth0=-1.3305046791897501 mm_toxe=-0.43863776587843545 mm_voff=-0.84102857871489944 mm_nfactor=-1.7882199099357545
VDP3LBUF3 dP3LBUF3 0 0.57422681156706212
XP3LBUF3 dP3LBUF3 g 0 0 sky130_fd_pr__nfet_01v8 w=0.42 l=4.0 mm_vth0=0.31629075219629238 mm_toxe=0.6387119399198089 mm_voff=0.87385785907668923 mm_nfactor=0.50720722628317361
VDP3LBUF4 dP3LBUF4 0 0.54961286141682364
XP3LBUF4 dP3LBUF4 g 0 0 sky130_fd_pr__nfet_01v8 w=0.42 l=4.0 mm_vth0=0.17179760174173339 mm_toxe=0.80373976495683708 mm_voff=0.49455838038116956 mm_nfactor=-0.56665112624123681
VDP3LBUF5 dP3LBUF5 0 0.57573486439467347
XP3LBUF5 dP3LBUF5 g 0 0 sky130_fd_pr__nfet_01v8 w=0.42 l=4.0 mm_vth0=-1.3595669472940923 mm_toxe=0.43284032292335511 mm_voff=0.28154151059422472 mm_nfactor=1.0826068810802312
VDP3LBUF6 dP3LBUF6 0 0.57939188121067975
XP3LBUF6 dP3LBUF6 g 0 0 sky130_fd_pr__nfet_01v8 w=0.42 l=4.0 mm_vth0=-1.0907666472665607 mm_toxe=0.48859077547252444 mm_voff=1.3668413763283143 mm_nfactor=-1.2581768269679048
VDP3LBUF7 dP3LBUF7 0 0.58622034657941335
XP3LBUF7 dP3LBUF7 g 0 0 sky130_fd_pr__nfet_01v8 w=0.42 l=4.0 mm_vth0=-1.7581714568749409 mm_toxe=1.0598742996513923 mm_voff=0.30894180386660741 mm_nfactor=1.1088690220286819
VDP3LBUF8 dP3LBUF8 0 0.57003692931927907
XP3LBUF8 dP3LBUF8 g 0 0 sky130_fd_pr__nfet_01v8 w=0.42 l=4.0 mm_vth0=0.60581918278107438 mm_toxe=2.6312699557353691 mm_voff=-1.2217535352131479 mm_nfactor=0.19559725314787046
VDP3LBUF9 dP3LBUF9 0 0.55590119787613868
XP3LBUF9 dP3LBUF9 g 0 0 sky130_fd_pr__nfet_01v8 w=0.42 l=4.0 mm_vth0=-0.51855318134832673 mm_toxe=1.9071216919290566 mm_voff=-0.10714058964628236 mm_nfactor=-0.31670870376732996
VDP3LBUF10 dP3LBUF10 0 0.57733478835708263
XP3LBUF10 dP3LBUF10 g 0 0 sky130_fd_pr__nfet_01v8 w=0.42 l=4.0 mm_vth0=0.76922691258706832 mm_toxe=1.7369204977147841 mm_voff=1.8641996107056995 mm_nfactor=2.0188661103172802
VDP3LBUF11 dP3LBUF11 0 0.5673616074058826
XP3LBUF11 dP3LBUF11 g 0 0 sky130_fd_pr__nfet_01v8 w=0.42 l=4.0 mm_vth0=0.33169775401535501 mm_toxe=-0.22633645721529858 mm_voff=-0.05653586462063314 mm_nfactor=0.44008854281474069
VDP3LBUF12 dP3LBUF12 0 0.56520481803645617
XP3LBUF12 dP3LBUF12 g 0 0 sky130_fd_pr__nfet_01v8 w=0.42 l=4.0 mm_vth0=0.60934306382100745 mm_toxe=-0.70387408040738064 mm_voff=0.11128689456235222 mm_nfactor=1.1013467811457016
VDP3LBUF13 dP3LBUF13 0 0.56659585168217408
XP3LBUF13 dP3LBUF13 g 0 0 sky130_fd_pr__nfet_01v8 w=0.42 l=4.0 mm_vth0=0.35983668561318338 mm_toxe=-0.23270666166059203 mm_voff=-0.21239074892742738 mm_nfactor=-0.60318163103787492
VDP3LBUF14 dP3LBUF14 0 0.58735719484985305
XP3LBUF14 dP3LBUF14 g 0 0 sky130_fd_pr__nfet_01v8 w=0.42 l=4.0 mm_vth0=-0.30272221900106416 mm_toxe=0.55785127764167364 mm_voff=-0.74633934544866232 mm_nfactor=0.97240254995846431
VDP3LBUF15 dP3LBUF15 0 0.56361055675023419
XP3LBUF15 dP3LBUF15 g 0 0 sky130_fd_pr__nfet_01v8 w=0.42 l=4.0 mm_vth0=0.783019088855755 mm_toxe=-0.94164209591172754 mm_voff=-1.1479168179989696 mm_nfactor=-0.65419650827423259
VDP3LBUF16 dP3LBUF16 0 0.56837813747115584
XP3LBUF16 dP3LBUF16 g 0 0 sky130_fd_pr__nfet_01v8 w=0.42 l=4.0 mm_vth0=-0.84563972821498934 mm_toxe=0.57450259711299489 mm_voff=0.24514085273086855 mm_nfactor=-0.24166001387957609
VDP3LBUF17 dP3LBUF17 0 0.57454233619060957
XP3LBUF17 dP3LBUF17 g 0 0 sky130_fd_pr__nfet_01v8 w=0.42 l=4.0 mm_vth0=-0.62949882529123891 mm_toxe=-1.6520279856452242 mm_voff=0.27906671776598962 mm_nfactor=-0.50831207161486702
VDP3LBUF18 dP3LBUF18 0 0.57242404201471409
XP3LBUF18 dP3LBUF18 g 0 0 sky130_fd_pr__nfet_01v8 w=0.42 l=4.0 mm_vth0=1.6915280305817311 mm_toxe=0.041585737628810161 mm_voff=0.015604300915189825 mm_nfactor=0.53774077800833964
VDP3LBUF19 dP3LBUF19 0 0.57421387163654403
XP3LBUF19 dP3LBUF19 g 0 0 sky130_fd_pr__nfet_01v8 w=0.42 l=4.0 mm_vth0=0.55818300184329861 mm_toxe=-2.1507801375746634 mm_voff=1.1574027907253517 mm_nfactor=0.88332401600097288
VDP3LBUF20 dP3LBUF20 0 0.55141710691468937
XP3LBUF20 dP3LBUF20 g 0 0 sky130_fd_pr__nfet_01v8 w=0.42 l=4.0 mm_vth0=1.9526750173175083 mm_toxe=-0.62628394698867973 mm_voff=-0.60185138026314 mm_nfactor=0.076878858361963717
.control
set filetype=binary
dc VG 0.2 1.8 5e-4
write div.raw i(VDP1L6T0) i(VDP1L6T1) i(VDP1L6T2) i(VDP1L6T3) i(VDP1L6T4) i(VDP1L6T5) i(VDP1L6T6) i(VDP1L6T7) i(VDP1L6T8) i(VDP1L6T9) i(VDP1L6T10) i(VDP1L6T11) i(VDP1L6T12) i(VDP1L6T13) i(VDP1L6T14) i(VDP1L6T15) i(VDP1L6T16) i(VDP1L6T17) i(VDP1L6T18) i(VDP1L6T19) i(VDP1L6T20) i(VDP1UINV0) i(VDP1UINV1) i(VDP1UINV2) i(VDP1UINV3) i(VDP1UINV4) i(VDP1UINV5) i(VDP1UINV6) i(VDP1UINV7) i(VDP1UINV8) i(VDP1UINV9) i(VDP1UINV10) i(VDP1UINV11) i(VDP1UINV12) i(VDP1UINV13) i(VDP1UINV14) i(VDP1UINV15) i(VDP1UINV16) i(VDP1UINV17) i(VDP1UINV18) i(VDP1UINV19) i(VDP1UINV20) i(VDP1LBUF0) i(VDP1LBUF1) i(VDP1LBUF2) i(VDP1LBUF3) i(VDP1LBUF4) i(VDP1LBUF5) i(VDP1LBUF6) i(VDP1LBUF7) i(VDP1LBUF8) i(VDP1LBUF9) i(VDP1LBUF10) i(VDP1LBUF11) i(VDP1LBUF12) i(VDP1LBUF13) i(VDP1LBUF14) i(VDP1LBUF15) i(VDP1LBUF16) i(VDP1LBUF17) i(VDP1LBUF18) i(VDP1LBUF19) i(VDP1LBUF20) i(VDP3L6T0) i(VDP3L6T1) i(VDP3L6T2) i(VDP3L6T3) i(VDP3L6T4) i(VDP3L6T5) i(VDP3L6T6) i(VDP3L6T7) i(VDP3L6T8) i(VDP3L6T9) i(VDP3L6T10) i(VDP3L6T11) i(VDP3L6T12) i(VDP3L6T13) i(VDP3L6T14) i(VDP3L6T15) i(VDP3L6T16) i(VDP3L6T17) i(VDP3L6T18) i(VDP3L6T19) i(VDP3L6T20) i(VDP3UINV0) i(VDP3UINV1) i(VDP3UINV2) i(VDP3UINV3) i(VDP3UINV4) i(VDP3UINV5) i(VDP3UINV6) i(VDP3UINV7) i(VDP3UINV8) i(VDP3UINV9) i(VDP3UINV10) i(VDP3UINV11) i(VDP3UINV12) i(VDP3UINV13) i(VDP3UINV14) i(VDP3UINV15) i(VDP3UINV16) i(VDP3UINV17) i(VDP3UINV18) i(VDP3UINV19) i(VDP3UINV20) i(VDP3LBUF0) i(VDP3LBUF1) i(VDP3LBUF2) i(VDP3LBUF3) i(VDP3LBUF4) i(VDP3LBUF5) i(VDP3LBUF6) i(VDP3LBUF7) i(VDP3LBUF8) i(VDP3LBUF9) i(VDP3LBUF10) i(VDP3LBUF11) i(VDP3LBUF12) i(VDP3LBUF13) i(VDP3LBUF14) i(VDP3LBUF15) i(VDP3LBUF16) i(VDP3LBUF17) i(VDP3LBUF18) i(VDP3LBUF19) i(VDP3LBUF20)
quit
.endc
.end
